; General functions for designing passive networks

; Convert series RL/RC to parallel
(defun qub::seriesToParallel (@key Rs Xs)
  Xp = (Rs**2 + Xs**2)/Xs
  Rp = (Rs**2 + Xs**2)/Rs
  (list nil 'Rp Rp 'Xp Xp))

; Convert parallel RL/RC to series
(defun qub::parallelToSeries (@key Rp Xp)
  ; Eqn shared by both
  core = (Rp*Xp)/(Rp**2 + Xp**2)
  Rs = core * Xp
  Xs = core * Rp
  (list nil 'Rs Rs 'Xs Xs))

; Calculate value of parallel resistors
(defun qub::parallelResistors (@rest args)
  (quotient 1.0 (qub::sum (mapcar (lambda (x) 1.0/x) args))))

; Reactance to capacitance
(defun qub::XToC (reactance angular_frequency)
  (quotient -1.0 (times reactance angular_frequency)))

; Reactance to inductance
(defun qub::XToL (reactance angular_frequency)
  (quotient reactance angular_frequency))

; Susceptance to capacitance
(defun qub::BToC (susceptance angular_frequency)
  (quotient susceptance angular_frequency))

; Susceptance to inductance
(defun qub::BToL (susceptance angular_frequency)
  (quotient -1.0 (times susceptance angular_frequency)))

(defun qub::GToR (conductance)
  (quotient 1.0 conductance))

(defun qub::ZToY (impedance)
  (quotient 1.0 impedance))

; Return plist of fields for R, L and C
(defun qub::ZToSeriesRLC (impedance angular_frequency)
  (list nil
        'R (real impedance)
        'L (qub::XToL (imag impedance) angular_frequency)
        'C (qub::XToC (imag impedance) angular_frequency)))

; Return plist of fields for R, L and C
(defun qub::YToParallelRLC (admittance angular_frequency)
  (list nil
        'R (qub::GToR (real admittance))
        'L (qub::BToL (imag admittance) angular_frequency)
        'C (qub::BToC (imag admittance) angular_frequency)))
