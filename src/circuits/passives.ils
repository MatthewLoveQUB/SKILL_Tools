; General functions for designing passive networks

; Convert series RL/RC to parallel
(defun qub::seriesToParallel (@key Rs Xs)
  Xp = (Rs**2 + Xs**2)/Xs
  Rp = (Rs**2 + Xs**2)/Rs
  (list nil 'Rp Rp 'Xp Xp))

; Convert parallel RL/RC to series
(defun qub::parallelToSeries (@key Rp Xp)
  ; Eqn shared by both
  core = (Rp*Xp)/(Rp**2 + Xp**2)
  Rs = core * Xp
  Xs = core * Rp
  (list nil 'Rs Rs 'Xs Xs))

; Calculate value of parallel resistors
(defun qub::parallelResistors (@rest args)
  (quotient 1.0 (qub::sum (mapcar (lambda (x) 1.0/x) args))))

; Reactance to capacitance
(defun qub::XToC (reactance angular_frequency)
  (quotient -1.0 (times reactance angular_frequency)))

; Reactance to inductance
(defun qub::XToL (reactance angular_frequency)
  (quotient reactance angular_frequency))

; Susceptance to capacitance
(defun qub::BToC (susceptance angular_frequency)
  (quotient susceptance angular_frequency))

; Susceptance to inductance
(defun qub::BToL (susceptance angular_frequency)
  (quotient -1.0 (times susceptance angular_frequency)))
