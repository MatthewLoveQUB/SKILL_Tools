; General functions for designing passive networks

; Convert series RL/RC to parallel
(defun qub::seriesToParallel (R X)
  Xp = (R**2 + X**2)/X
  Rp = (R**2 + X**2)/R
  (list nil 'Rp Rp 'Xp Xp))

; Convert parallel RL/RC to series
(defun qub::parallelToSeries (Rp Xp)
  ; Eqn shared my both
  core = (Rp*Xp)/(Rp**2 + Xp**2)
  Rs = core * Xp
  Xs = core * Rp
  (list nil 'Rs Rs 'Xs Xs))

; Calculate value of parallel resistors
(defun qub::parallelResistors (@rest args)
  (quotient 1.0 (qub::sum (mapcar (lambda (x) 1.0/x) args))))

(defun qub::XToC (reactance angular_frequency)
  (quotient -1.0 (times reactance angular_frequency)))

(defun qub::XToL (reactance angular_frequency)
  (quotient reactance angular_frequency))

(defun qub::BToC (susceptance angular_frequency)
  (quotient susceptance angular_frequency))

(defun qub::BToL (susceptance angular_frequency)
  (quotient -1.0 (times susceptance angular_frequency)))
