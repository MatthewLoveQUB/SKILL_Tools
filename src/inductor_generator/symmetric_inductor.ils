;;;; Module for generating a spiral inductor
(defun qub::getSymmetricSpiralPoints (@key
                                      (turns 2)
                                      (width 10.0)
                                      (spacing 5.0)
                                      (apothem 50.0)
                                      (nsides 8)
                                      (rotation_anticlockwise 0.0)
                                      (ref 0.0:0.0))
  (letseq (; format of spiralCoords:
           ; spiralCoords = (turn0 turn1 turn2 ... turnN)
           ; turnN = (left right)
           ; right = (point0 point1 ... pointN)
           (spiralCoords nil)
           ; For the connecting bridges in the lower metal level
           (bridgeCoords nil)
           (maxTurnIdx (sub1 turns))
           (maxPointIdx (sub1 nsides))
           (atc qub::apothemToCircumradius)
           (circumradius (atc (plus (quotient width 2.0) apothem) nsides))
           (getPoint (lambda (polyIdx pointIdx)
                       (qub::getPolyPoint polyIdx
                                          pointIdx
                                          nsides
                                          circumradius
                                          spacing
                                          width
                                          ?rotation_anticlockwise
                                            rotation_anticlockwise
                                          ?ref ref)))
           (addPorts (lambda (lst firstPoint lastPoint)
                       (letseq ((mp (lambda (x)
                                      (qub::midPoint firstPoint
                                                     lastPoint
                                                     ?distAlong x)))
                                (p1 (mp (quotient 1.0 3.0)))
                                (p2 (mp (quotient 2.0 3.0))))
                         (setq lst (cons p1 lst))
                         (setq lst (reverse lst))
                         (setq lst (cons p2 lst))
                         lst)))
           ; Creates coordinates for a single turn spiral inductor
           (oneTurn (lambda ()
                      (let ((firstPoint  (getPoint maxTurnIdx 0))
                            (lastPoint (getPoint maxTurnIdx maxPointIdx))
                            (pts nil))
                         (for pointIdx 0 maxPointIdx
                             (pushf (getPoint maxTurnIdx pointIdx) pts))
                         (pushf (list (addPorts pts firstPoint lastPoint))
                                spiralCoords))))
           ; Gets coordinates for a multi turn spiral inductor
           (multiTurn (lambda ()
                        (let ((curSide (if (evenp turns)
                                           'bottom
                                           'top))
                              (bridgePoint (if (eq curSide 'top)
                                               'bottom
                                               'top)))
                          (for turnIdx 0 maxTurnIdx
                            t)))))
        ; Conditional to call the appropriate function
        (cond ((equal turns 1) (oneTurn))
              (t (multiTurn)))
        (list spiralCoords bridgeCoords)))

(defun qub::drawSymmetricInductor (@key
                                   (turns 1)
                                   (width 10.0)
                                   (spacing 5.0)
                                   (apothem 50.0)
                                   (nsides 8)
                                   (topMetalLayer "M1")
                                   (bottomMetalLayer "M2")
                                   (rotation_anticlockwise 0.0)
                                   (ref 0.0:0.0))
  (let ((points (qub::getSymmetricSpiralPoints ?turns turns
                                               ?width width
                                               ?spacing spacing
                                               ?apothem apothem
                                               ?nsides nsides
                                               ?rotation_anticlockwise
                                                 rotation_anticlockwise
                                               ?ref ref))
        (offset 0))
    (let ((spiralCoords (car points))
          (bridgeCoords (cadr points))
          (cp (lambda (pts metLyr)
                (leCreatePath (geGetEditCellView)
                              (list metLyr)
                              pts
                              width
                              "truncateExtend"
                              offset
                              "center"))))
      (foreach turn spiralCoords
        (foreach half turn
          (unless (null half)
            (cp half topMetalLayer))))
      (unless (zerop (length bridgeCoords))
        (cp bridgeCoords bottomMetalLayer)))))

(printf "%A\n" (qub::getSymmetricSpiralPoints ?turns 1))
(qub::drawSymmetricInductor ?turns 1)
