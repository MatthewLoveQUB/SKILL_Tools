;;;; Module for generating a spiral inductor
(defun qub::getSymmetricSpiralPoints (@key
                                      (turns 2)
                                      (width 10.0)
                                      (spacing 5.0)
                                      (apothem 50.0)
                                      (nsides 8)
                                      (rotation_anticlockwise 0.0)
                                      (ref 0.0:0.0))
  (let ((spiralCoords nil)
        (bridgeCoords nil)
        (circumradius (qub::apothemToCircumradius (plus
                                                    (quotient
                                                      width
                                                      2.0)
                                                    apothem)
                                                  nsides)))
    (let ((getPoint (lambda (polyIdx pointIdx)
                      (qub::getPolyPoint polyIdx
                                         pointIdx
                                         nsides
                                         circumradius
                                         spacing
                                         width
                                         ?rotation_anticlockwise
                                           rotation_anticlockwise
                                         ?ref ref)))
          (maxTurnIdx (sub1 turns))
          (maxPointIdx (sub1 nsides)))
      (let ((getSingleTurn (lambda ()
              (for pointIdx 0 maxPointIdx
                (pushf (getPoint maxTurnIdx pointIdx) spiralCoords))
              ; Now add the ports
              (let ((firstPoint  (getPoint maxTurnIdx 0))
                    (lastPoint (getPoint maxTurnIdx maxPointIdx)))
                (pushf (qub::midPoint firstPoint
                                      lastPoint
                                      ?distAlong (quotient 2.0 3.0))
                       spiralCoords)
                (append1 spiralCoords
                         (qub::midPoint firstPoint
                                        lastPoint
                                        ?distAlong (quotient 1.0 3.0)))))))
        (cond ((equal turns 1) (getSingleTurn))
              (t (error "jjkj")))
        (list spiralCoords bridgeCoords)))))

(printf "%A\n" (qub::getSymmetricSpiralPoints ?turns 1))
