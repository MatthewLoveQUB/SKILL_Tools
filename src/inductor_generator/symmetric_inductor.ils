;;;; Module for generating a spiral inductor

; Extends the middle sections so they're closer together
;  _       _
; /         \
; |         |
;
; versus
;
;  ___   ___
; /         \
; |         |

(defmacro qub:::__portHelper (fn1 x fn2 y p)
  `(unless (equal (,fn1 ,x) (,fn2 ,y))
    (,p (,fn1 ,x) ,y)))

(defun qub::addPorts (turn ref width nturns turnIdx)
  (letseq ((left (qub::sortTopPoint turn->left))
           (right (qub::sortTopPoint turn->right))
           (getPort
             (lambda (left right)
               (let ((mp (qub::midPoint left right ?distAlong 0.5)))
                 (list (qub::rightPoint left (qub::mvPtX mp -width))
                       (qub::leftPoint right (qub::mvPtX mp width))))))
           (topPorts (getPort (car left) (car right)))
           (bottomPorts (getPort (qub::lastAtom left) (qub::lastAtom right)))
           (mutLast (lambda (lst obj) (setcar (last lst) obj))))
    (let ((f (if (or (and (evenp nturns) (evenp turnIdx))
                     (and (oddp nturns) (oddp turnIdx)))
             (lambda (p) (mutLast p (qub::mvPtX (cadr p) (width * -0.2))))
             (lambda (p) (setcar p (qub::mvPtX (car p) (width * 0.2)))))))
      (mapcar f (list topPorts bottomPorts)))

    ; Making sure that there are no duplicate coordinates added
    (qub:::__portHelper car topPorts car left pushf)
    (qub:::__portHelper cadr topPorts car right pushf)
    (qub:::__portHelper car bottomPorts qub::lastAtom left qub::pushEnd)
    (qub:::__portHelper cadr bottomPorts qub::lastAtom right qub::pushEnd)
    (list nil 'left left 'right right)))

(defun qub::getBridgePoints (getPoint bridgePoint maxPointIdx maxHalfPointIdx)
  (let ((gp (lambda (x) (getPoint 0 x)))
        (x maxPointIdx)
        (y maxHalfPointIdx))
    (if (eq bridgePoint 'bottom)
        (mapcar gp (list 1 0 x (x - 1)))
        (mapcar gp (list (y - 1) y (y + 1) (y + 2))))))

(defun qub::invertSide (side)
  (if (eq side 'top)
      'bottom
      'top))

(defun qub:::getInterconnectsHelper (side refPts i width)
  (letseq ((f (if (eq side 'top)
                  qub::sortTopPoint
                  qub::sortBottomPoint))
           (innerPts (nth i refPts))
           (outerPts (nth (i + 1) refPts))
           (getDist (lambda (x) (qub::getDist (car x) (cadr x))))
           (a2p (lambda (x) (qub::getAngleToPt (car x) (cadr x))))
           (getLst
             (lambda (leftPts rightPts)
               (letseq ((points nil)
                        (leftAngle (a2p leftPts))
                        (rightAngle (a2p rightPts))
                        (maa (lambda (p a)
                         (qub::moveAtAngle (car p) (min width (getDist p)) a))))
                 (pushf (maa leftPts leftAngle) points)
                 (pushf (car leftPts) points)
                 (pushf (car rightPts) points)
                 (pushf (maa rightPts rightAngle) points)
                 points)))
           (il2or (getLst (f innerPts->left) (f outerPts->right)))
           (ol2ir (getLst (f outerPts->left) (f innerPts->right))))
    (if (eq side 'top)
        (list nil 'top ol2ir 'bot il2or)
        (list nil 'top il2or 'bot ol2ir))))

; gbp = getbridgepoint
(defun qub::getInterconnects (width points gbp turns)
  (letseq ((pts (list nil 'topMetal nil 'botMetal nil))
           ; Outer loop connects to nothing
           (maxPtIdx ((length points) - 2))
           (side (if (evenp turns)
                     'top
                     'bottom)))
    (pushf (gbp) pts->topMetal) ; Adding m1 connection to innermost loop
    (for i 0 maxPtIdx
      (let ((interconnects (qub:::getInterconnectsHelper side points i width)))
        (pushf interconnects->top pts->topMetal)
        (pushf interconnects->bot pts->botMetal))
      (setq side (qub::invertSide side)))
    pts))

; Arranges the list so the upper point is the car
; The order of the points is unchanged
(defun qub::sortTopPoint (points)
  (if (qub::higherp (car points) (qub::lastAtom points))
      points
      (reverse points)))

(defun qub::sortBottomPoint (pts)
  (reverse (qub::sortTopPoint pts)))

(defun qub::getSymmetricSpiralPoints (@key
                                      (turns 2)
                                      (width 10.0)
                                      (spacing 5.0)
                                      (apothem 50.0)
                                      (nsides 8)
                                      (rotation_anticlockwise 0.0)
                                      (ref 0.0:0.0))
  (letseq (; format of spiralCoords:
           ; spiralCoords = (turn0 turn1 turn2 ... turnN)
           ; turnN = (left right)
           ; right = (point0 point1 ... pointN)
           (atc qub::apothemToCircumradius)
           (getPoint
            (lambda (polyIdx pointIdx)
              (qub::getPolyPoint
                polyIdx
                pointIdx
                nsides
                (atc (plus apothem (width / 2.0)) nsides)
                spacing
                width
                ?rotation_anticlockwise rotation_anticlockwise
                ?ref ref)))
           (maxPointIdx (nsides - 1))
           (maxTurnIdx (turns - 1))
           (maxHalfPointIdx ((nsides / 2) - 1))
           (gbp
            (lambda ()
              (qub::getBridgePoints
                getPoint
                (if (evenp turns)
                    'top
                    'bottom)
                maxPointIdx
                maxHalfPointIdx)))
           (spiralCoords nil))
    (for turnIdx 0 maxTurnIdx
      (let ((turn (list nil 'left nil 'right nil)))
        (for pIdx 0 maxHalfPointIdx
          (pushf (getPoint turnIdx pIdx) turn->left)
          (pushf (getPoint turnIdx (maxPointIdx - pIdx)) turn->right))
        (pushf turn spiralCoords)))

    ; fixing the order of the spiral coords
    (setq spiralCoords (reverse spiralCoords))

    ; Add the extra metal to reduce the gap between each half of the turns
    (setq spiralCoords (mapcar (lambda (trn i) (qub::addPorts trn ref width turns i))
                               spiralCoords
                               (qub::range ?stop (length spiralCoords))))

    (let ((interconnects (qub::getInterconnects width spiralCoords gbp turns)))
      (list spiralCoords interconnects))))
