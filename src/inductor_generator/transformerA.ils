; Two coils some space apart

(defclass qub::transformerA (qub::symmInductorPCell)
  ((coilSpacing @initform (qub::defineParam "float" 5.0))
   (coilRotation @initform (qub::defineParam "string" "R0 R180"))
   (secondCoilDirection @initform (qub::defineParam "string" "up"))
   (allowOverlap @initform (qub::defineParam "boolean" "FALSE"))))

(defmethod qub::draw ((device qub::transformerA))
  (letseq ((coilSpacing (qub::getParamValue device 'coilSpacing))
           (rotation (parseString (qub::getParamValue device 'coilRotation)))
           (dir (qub::getParamValue device 'secondCoilDirection))
           (metalLayers (parseString (qub::getParamValue device 'metalStack)))
           (allowOverlap
             (nequal "FALSE" (qub::getParamValue device 'allowOverlap)))
           (portLength (qub::getParamValue device 'portLength))
           (cv (slotValue device 'cvId))
           (setMet (lambda (m1 m2)
                     (qub::setParamValue device
                                    'metalStack
                                    (sprintf nil "%s %s" m1 m2))))
           (createInd (lambda (name m1 m2)
                         (setMet m1 m2)
                         (let ((figGroup (callNextMethod)))
                           (putprop figGroup name 'name)
                           figGroup)))
           (fg1 (createInd "Group1" (nth 0 metalLayers) (nth 1 metalLayers)))
           (fg2 (createInd "Group2" (nth 2 metalLayers) (nth 3 metalLayers)))
           (calc (lambda (x y)
                   (if allowOverlap
                       0
                       ((x fg1) - (y fg1)))))
           (height (calc topEdge bottomEdge))
           (width  (calc rightEdge leftEdge))
           (fn (lambda (refDir x)
                 (if (dir == refDir)
                     (x + coilSpacing - portLength)
                     (0 - x - coilSpacing))))
           (transform (if (member dir (list "up" "down"))
                          (list 0 (fn "up" height))
                          (list (fn "right" width) 0))))
      (dbMoveFig fg1 cv (list 0:0 (car rotation)))
      (dbMoveFig fg2 cv (list transform (cadr rotation)))))

(defmacro qub::createTransformerA (@key (library nil)
                                        (defaultTopMetalLayer nil)
                                        (defaultTopMinusOneMetalLayer nil))
  (letseq ((cellName "transformerA")
           (cellType "layout")
           (cellObj (ddGetObj library cellName)))
    ; Delete the cell if it doesn't exist
    ; As re-running the macro doesn't seem to refresh the PCell instance
    (if cellObj
        (ddDeleteObj cellObj))
    `(pcDefinePCell
      (list (ddGetObj ,library) ,cellName ,cellType)
      ((turns "int" 2)
       (width "float" 10.0)
       (spacing "float" 5.0)
       (apothem "float" 50.0)
       (nsides "int" 8)
       (coilSpacing "float" 5.0)
       (coilRotation "string" "R0 R180")
       (secondCoilDirection "string" "up")
       (allowOverlap "boolean" "FALSE")
       (metalStack "string"
                   (strcat ,defaultTopMetalLayer
                           " "
                           ,defaultTopMinusOneMetalLayer
                           " "
                           ,defaultTopMetalLayer
                           " "
                           ,defaultTopMinusOneMetalLayer))
       (portLength "float" 25.0))
      (let ((pcell (makeInstance 'qub::transformerA)))
        (qub::setPcellParams pcell pcCellView)
        (qub::draw pcell)))))
