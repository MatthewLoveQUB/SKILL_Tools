; Two coils some space apart

(defclass qub::transformerA (qub::symmInductorPCell)
  ((coilSpacing @initform (qub::defineParam "float" 5.0))
   (coilRotation @initform (qub::defineParam "string" "R0 R180"))
   (secondCoilDirection @initform (qub::defineParam "string" "up"))
   (allowOverlap @initform (qub::defineParam "boolean" "FALSE"))))

(defmethod qub::draw ((device qub::transformerA))
  (letseq ((coilSpacing (qub::getParamValue device 'coilSpacing))
           (rotation (parseString (qub::getParamValue device 'coilRotation)))
           (dir (qub::getParamValue device 'secondCoilDirection))
           (metalLayers (parseString (qub::getParamValue device 'metalStack)))
           (allowOverlap (nequal "FALSE" (qub::getParamValue device 'allowOverlap)))
           (cv (slotValue device 'cvId))
           (setMet (lambda (m1 m2)
                     (qub::setParamValue device
                                    'metalStack
                                    (sprintf nil "%s %s" m1 m2))))
           (createInd (lambda (name m1 m2)
                         (setMet m1 m2)
                         (let ((figGroup (callNextMethod)))
                           (putprop figGroup name 'name)
                           figGroup)))
           (figGroup1 (createInd "Group1"
                                 (nth 0 metalLayers)
                                 (nth 1 metalLayers)))
           (figGroup2 (createInd "Group2"
                                 (nth 2 metalLayers)
                                 (nth 3 metalLayers)))
           (height (if allowOverlap
                       0
                       (difference (topEdge figGroup1) (bottomEdge figGroup1))))
           (width (if allowOverlap
                      0
                      (difference (rightEdge figGroup1) (leftEdge figGroup1))))
           (transform (if (member dir (list "up" "down"))
                          (list 0 (if (equal dir "up")
                                      (plus height coilSpacing)
                                      (difference 0 height coilSpacing)))
                          (list (if (equal dir "right")
                                    (plus width coilSpacing)
                                    (difference 0 width coilSpacing))
                                0))))
      (dbMoveFig figGroup1 cv (list 0:0 (car rotation)))
      (dbMoveFig figGroup2 cv (list transform (cadr rotation)))))

(defmacro qub::createTransformerA (library)
  `(pcDefinePCell
    (list (ddGetObj ,library) "transformerA" "layout")
    ((turns "int" 2)
     (width "float" 10.0)
     (spacing "float" 5.0)
     (apothem "float" 50.0)
     (nsides "int" 8)
     (coilSpacing "float" 5.0)
     (coilRotation "string" "R0 R180")
     (secondCoilDirection "string" "up")
     (allowOverlap "boolean" "FALSE")
     (metalStack "string" "M1 M2 M1 M2"))
    (let ((pcell (makeInstance 'qub::transformerA)))
      (qub::setPcellParams pcell pcCellView)
      (qub::draw pcell))))
