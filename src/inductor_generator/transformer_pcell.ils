(defclass transformerPCell_A (symmInductorPCell)
  ((coilSpacing @initform (defineParam "float" 50.0))))

(defmethod draw ((device transformerPCell_A))
  (letseq ((coilSpacing (getParamValue device 'coilSpacing))
           (cv (slotValue device 'cvId))
           (createInd (lambda (name)
                         (let ((figGroup (callNextMethod)))
                           (putprop figGroup name 'name)
                           figGroup)))
           (figGroup1 (createInd "Group1"))
           (figGroup2 (createInd "Group2"))
           (rightSide (rightEdge figGroup1->bBox))
           (leftSide (leftEdge figGroup1->bBox))
           (width (difference rightSide leftSide))
           (newX (plus width coilSpacing)))
      (dbMoveFig figGroup2 cv (list newX:0.0 "R0"))))

(defmacro qub::createTransformerPCell (library)
  `(pcDefinePCell
    (list (ddGetObj ,library) "transformerPCell_A" "layout")
    ((turns "int" 2)
     (width "float" 10.0)
     (spacing "float" 5.0)
     (apothem "float" 50.0)
     (nsides "int" 8)
     (topMetalLayer "string" "M1")
     (bottomMetalLayer "string" "M2")
     (coilSpacing "float" 50.0))
    (let ((pcell (makeInstance 'transformerPCell_A)))
      (setPcellParams pcell pcCellView)
      (draw pcell))))
