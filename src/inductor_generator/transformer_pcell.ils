(defclass transformerPCell (PcellParam)
  ((turns @initform (defineParam "int" 2))
   (width @initform (defineParam "float" 10.0))
   (spacing @initform (defineParam "float" 5.0))
   (apothem @initform (defineParam "float" 50.0))
   (nsides @initform (defineParam "int" 8))
   (topMetalLayer @initform (defineParam "string" "M1"))
   (bottomMetalLayer @initform (defineParam "string" "M2"))
   (coilSpacing @initform (defineParam "float" 10.0))))

(defmethod draw ((device transformerPCell))
  (letseq ((turns (getParamValue device 'turns))
           (w (getParamValue device 'width))
           (s (getParamValue device 'spacing))
           (a (getParamValue device 'apothem))
           (n (getParamValue device 'nsides))
           (tml (getParamValue device 'topMetalLayer))
           (bml (getParamValue device 'bottomMetalLayer))
           (cs (getParamValue device 'coilSpacing))
           (cv (slotValue device 'cvId))
           (points (qub::getSymmetricSpiralPoints ?turns turns
                                                  ?width w
                                                  ?spacing s
                                                  ?apothem a
                                                  ?nsides n
                                                  ?rotation_anticlockwise 45.0))
           (offset 0)
           (spiralCoords (car points))
           (bridgeCoords (cadr points))
           (objects nil)
           (figGroups nil)
           (mode "truncateExtend")
           (cp (lambda (pts metLyr)
                 (pushf (dbCreatePath cv (list metLyr) pts w mode) objects))))

    (foreach groupName (list "Group1" "Group2")
      ; Generating main turns
      (foreach turn spiralCoords
        (foreach half turn
          (cp half tml)))

      ; Generating interconnects
      (let ((topMetalBridges (car bridgeCoords))
            (bottomMetalBridges (cadr bridgeCoords))
            (drawPts (lambda (pts metal) (foreach p pts (cp p metal)))))
        (drawPts topMetalBridges tml)
        (drawPts bottomMetalBridges bml))

      ; creating a fig group to organise the parts
      (let ((fg (dbCreateFigGroup cv groupName t 0.0:0.0 "R0")))
        (foreach o objects
          (dbAddFigToFigGroup fg o))
        (when (equal groupName "Group2")
        	(letseq ((lastFg (car figGroups))
                   (rightSide (xCoord (cadr lastFg->bBox)))
                   (leftSide (xCoord (car lastFg->bBox)))
                   (width (difference rightSide leftSide))
                   (newX (plus width cs)))
            (dbMoveFig fg cv (list newX:0.0 "R0"))))
        (pushf fg figGroups)))
    (callNextMethod)))

(defmacro qub::createTransformerPCell (library)
  `(pcDefinePCell
    (list (ddGetObj ,library) "transformerPCell_A" "layout")
    ((turns "int" 2)
     (width "float" 10.0)
     (spacing "float" 5.0)
     (apothem "float" 50.0)
     (nsides "int" 8)
     (topMetalLayer "string" "M1")
     (bottomMetalLayer "string" "M2")
     (coilSpacing "float" 50.0))
    (let ((pcell (makeInstance 'transformerPCell)))
      (setPcellParams pcell pcCellView)
      (draw pcell))))

; (qub:::createTransformerPCell "mlove_lib" "transformerPCell")
