(defclass transformerPCell_A (symmInductorPCell)
  ((coilSpacing @initform (defineParam "float" 50.0))))

(defmethod draw ((device transformerPCell_A))
  (callNextMethod))

(defmacro qub::createTransformerPCell (library)
  `(pcDefinePCell
    (list (ddGetObj ,library) "transformerPCell_A" "layout")
    ((turns "int" 2)
     (width "float" 10.0)
     (spacing "float" 5.0)
     (apothem "float" 50.0)
     (nsides "int" 8)
     (topMetalLayer "string" "M1")
     (bottomMetalLayer "string" "M2")
     (coilSpacing "float" 50.0))
    (let ((pcell1 (makeInstance 'transformerPCell_A))
          (pcell2 (makeInstance 'transformerPCell_A)))
      (setPcellParams pcell1 pcCellView)
      (setPcellParams pcell2 pcCellView)
      (let ((figGroup1 (draw pcell1)))
        (figGroup1->name = "Group1")
        (let ((figGroup2 (draw pcell2)))
          (figGroup2->name = "Group2")
          (letseq ((rightSide (rightEdge figGroup1->bBox))
                   (leftSide (leftEdge figGroup1->bBox))
                   (width (difference rightSide leftSide))
                   (newX (plus width coilSpacing)))
            (dbMoveFig figGroup2 pcCellView (list newX:0.0 "R0"))))))))
