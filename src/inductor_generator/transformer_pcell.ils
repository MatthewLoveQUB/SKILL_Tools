(defclass transformerPCell_A (symmInductorPCell)
  ((coilSpacing @initform (defineParam "float" 5.0))
   (coilOneRotation @initform (defineParam "string" "R0"))
   (coilTwoRotation @initform (defineParam "string" "R180"))
   (secondCoilDirection @initform (defineParam "string" "up"))))

(defmethod draw ((device transformerPCell_A))
  (letseq ((coilSpacing (getParamValue device 'coilSpacing))
           (rot1 (getParamValue device 'coilOneRotation))
           (rot2 (getParamValue device 'coilTwoRotation))
           (dir (getParamValue device 'secondCoilDirection))
           (cv (slotValue device 'cvId))
           (createInd (lambda (name)
                         (let ((figGroup (callNextMethod)))
                           (putprop figGroup name 'name)
                           figGroup)))
           (figGroup1 (createInd "Group1"))
           (figGroup2 (createInd "Group2"))
           (height (difference (topEdge figGroup1) (bottomEdge figGroup1)))
           (width (difference (rightEdge figGroup1) (leftEdge figGroup1)))
           (transform (if (member dir (list "up" "down"))
                          (list 0 (if (equal dir "up")
                                      (plus height coilSpacing)
                                      (difference 0 height coilSpacing)))
                          (list (if (equal dir "right")
                                    (plus width coilSpacing)
                                    (difference 0 width coilSpacing))
                                0))))
      (printf "DIR %A\n" dir)
      (dbMoveFig figGroup1 cv (list 0:0 rot1))
      (dbMoveFig figGroup2 cv (list transform rot2))))

(defmacro qub::createTransformerPCell (library)
  `(pcDefinePCell
    (list (ddGetObj ,library) "transformerPCell_A" "layout")
    ((turns "int" 2)
     (width "float" 10.0)
     (spacing "float" 5.0)
     (apothem "float" 50.0)
     (nsides "int" 8)
     (topMetalLayer "string" "M1")
     (bottomMetalLayer "string" "M2")
     (coilSpacing "float" 5.0)
     (coilOneRotation "string" "R0")
     (coilTwoRotation "string" "R180")
     (secondCoilDirection "string" "up"))
    (let ((pcell (makeInstance 'transformerPCell_A)))
      (setPcellParams pcell pcCellView)
      (draw pcell))))
