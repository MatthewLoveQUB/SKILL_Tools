(qubCreateModule "inductor_generator/"
  (modload "inductor.ils")
  (modload "spiral_inductor.ils")
  (modload "ind_pcell.ils")
  (modload "oct_ind_pcell.ils")
  (modload "symmetric_inductor.ils")
  (modload "symm_ind_pcell.ils")
  (modload "transformerA.ils")
  (modload "transformerB.ils"))

(defmacro qub::createInductorPCells (libname)
  (list `(lambda (@rest x) (printf "Created PCells in %s" ,libname))
        `(qub::createInductorPCell ,libname)
        `(qub::createOctInductorPCell ,libname)
        `(qub::createSymmInductorPCell ,libname)
        `(qub::createTransformerA ,libname)
        `(qub::createTransformerB ,libname)))

(defun qub::loadFrlanPCells ()
  (load "./code/src/inductor_generator/frlan.ils")
  (load "./code/src/inductor_generator/frlanMultiMetal.ils"))
