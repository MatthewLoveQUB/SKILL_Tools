; Finds a point at a distance and angle from a reference point
(defun qub::getPoint (angle dist @key (ref 0.0:0.0))
  (let ((x (xCoord ref))
        (y (yCoord ref))
        (dx (dist * (cos (qub::degToRad angle))))
        (dy (dist * (sin (qub::degToRad angle)))))
    (range (x + dx) (y + dy))))

; equation taken from here the Line-Line intersection wiki page
(defun qub:::findIntersectPoint (a1 a2 b1 b2)
  (let ((x1 (xCoord a1))
        (x2 (xCoord a2))
        (x3 (xCoord b1))
        (x4 (xCoord b2))
        (y1 (yCoord a1))
        (y2 (yCoord a2))
        (y3 (yCoord b1))
        (y4 (yCoord b2)))
    (let ((x1y2 (x1 * y2))
          (y1x2 (y1 * x2))
          (x3y4 (x3 * y4))
          (y3x4 (y3 * x4)))
      (let ((denominator (difference
                           ((x1 - x2) * (y3 - y4))
                           ((y1 - y2) * (x3 - x4)))))
        (let ((px (quotient
                    (difference
                      ((x1y2 - y1x2) * (x3 - x4))
                      ((x1 - x2) * (x3y4 - y3x4)))
                    denominator))
              (py (quotient
                    (difference
                      ((x1y2 - y1x2) * (y3 - y4))
                      ((y1 - y2) * (x3y4 - y3x4)))
                    denominator)))
          px:py)))))

; 0 = half of the internal angle e.g. 45 for a square
; 1 = next point anticlockwise = 135 for a square
(defun qub::getPolyPoint (polyIdx
                          pointIdx
                          nsides
                          circumradius
                          spacing
                          width
                          @key
                          (ref 0.0:0.0)
                          (rotation_anticlockwise 0.0))
  (let ((dist (plus
                circumradius
                (times
                  polyIdx
                  (plus
                    (qub::apothemToCircumradius spacing nsides)
                    (qub::apothemToCircumradius width nsides)))))
        (angle (plus
		             (difference 90.0 (quotient (qub::internalAngle nsides) 2.0))
                 rotation_anticlockwise
                 (pointIdx * (qub::internalAngle nsides)))))
    (qub::getPoint (qub::fixAngle angle) dist ?ref ref)))
