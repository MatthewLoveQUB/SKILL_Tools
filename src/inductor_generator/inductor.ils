; Finds a point at a distance and angle from a reference point
(defun qub::getPoint (angle dist @key (ref 0.0:0.0))
  (let ((x (xCoord ref))
        (y (yCoord ref))
        (dx (dist * (cos (qub::degToRad angle))))
        (dy (dist * (sin (qub::degToRad angle)))))
    (range (x + dx) (y + dy))))

; 0 = half of the internal angle e.g. 45 for a square
; 1 = next point anticlockwise = 135 for a square
(defun qub::getPolyPoint (polyIdx
                          pointIdx
                          nsides
                          circumradius
                          spacing
                          width
                          @key
                          (ref 0.0:0.0)
                          (rotation_anticlockwise 0.0))
  (let ((a2c qub::apothemToCircumradius)
        (fa qub::fixAngle)
        (ia qub::internalAngle)
        (n nsides))
    (let ((d (circumradius + (polyIdx * ((a2c spacing n) + (a2c width n)))))
          (angle (plus
                   (difference 90.0 ((ia nsides) / 2.0))
                   rotation_anticlockwise
                   (pointIdx * (ia nsides)))))
      (qub::getPoint (fa angle) d ?ref ref))))
