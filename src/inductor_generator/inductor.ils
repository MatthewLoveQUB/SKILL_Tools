;;;; file for generating spiral inductors
;;;; only use floats for coordinates
;;;; 0 degrees is east. 90 degrees is north

(defgeneric qub::fixAngle (angle))

(defmethod qub::fixAngle ((angle fixnum))
  (modulo angle 360))

(defmethod qub::fixAngle ((angle flonum))
  (if (negativep angle)
      (plus 360.0 (modf angle 360.0))
  (modf angle 360.0)))

(defun qub::apothemToCircumradius (apothem num_sides)
  (quotient
    apothem
    (cos (quotient
           qub::m.PI
           num_sides))))

; Finds the internal angle of a regular polygon
(defun qub::internalAngle (sides)
  (quotient
    360.0
    sides))

; Degrees to radians
(defun qub::degToRad (value)
  (times
    qub::m.PI
    (quotient
      value
      180.0)))

; Finds a point at a distance and angle from a reference point
(defun qub::getPoint (angle dist @key (ref 0.0:0.0))
  (let ((x (xCoord ref))
        (y (yCoord ref))
        (dx (times
              dist
              (cos (qub::degToRad angle))))
        (dy (times
              dist
              (sin (qub::degToRad angle)))))
    (range
      (plus x dx)
      (plus y dy))))

; equation taken from here the Line-Line intersection wiki page
(defun qub:::findIntersectPoint (a1 a2 b1 b2)
  (let ((x1 (xCoord a1))
        (x2 (xCoord a2))
        (x3 (xCoord b1))
        (x4 (xCoord b2))
        (y1 (yCoord a1))
        (y2 (yCoord a2))
        (y3 (yCoord b1))
        (y4 (yCoord b2)))
    (let ((x1y2 (times x1 y2))
          (y1x2 (times y1 x2))
          (x3y4 (times x3 y4))
          (y3x4 (times y3 x4)))
      (let ((denominator (difference
                           (times
                             (difference x1 x2)
                             (difference y3 y4))
                           (times
                             (difference y1 y2)
                             (difference x3 x4)))))
      (let ((px (quotient
                  (difference
                    (times
                      (difference x1y2 y1x2)
                      (difference x3 x4))
                    (times
                      (difference x1 x2)
                      (difference x3y4 y3x4)))
                  denominator))
            (py (quotient
                  (difference
                    (times
                      (difference x1y2 y1x2)
                      (difference y3 y4))
                    (times
                      (difference y1 y2)
                      (difference x3y4 y3x4)))
                  denominator)))
        px:py)))))

; 0 = half of the internal angle e.g. 45 for a square
; 1 = next point anticlockwise = 135 for a square
(defun qub::getPolyPoint (polyIdx
                          pointIdx
                          nsides
                          circumradius
                          spacing
                          width
                          @key
                          (ref 0.0:0.0)
                          (rotation_anticlockwise 0.0))
  (let ((dist (plus
                circumradius
                (times
                  polyIdx
                  (plus
                    (qub::apothemToCircumradius spacing nsides)
                    (qub::apothemToCircumradius width nsides)))))
        (angle (plus
		             (difference 90.0 (quotient (qub::internalAngle nsides) 2.0))
                 rotation_anticlockwise
                 (times
                   pointIdx
                   (qub::internalAngle nsides)))))
    (qub::getPoint (qub::fixAngle angle) dist ?ref ref)))

(defun qub::midPoint (p1 p2 @key (distAlong 0.5))
  (let ((p1Scalar distAlong)
        (p2Scalar (difference 1.0 distAlong)))
  (range
    (plus (times p1Scalar (xCoord p1)) (times p2Scalar (xCoord p2)))
    (plus (times p1Scalar (yCoord p1)) (times p2Scalar (yCoord p2))))))
