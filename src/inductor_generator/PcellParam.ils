; Base class for all Pcells.
; cvId will hold the pcCellView value
(defclass PcellParam ()
  ((cvId @initarg cvId)))

; A simple method to populate the Pcell parameters from the super master to
; a Pcell device's slots
(defmethod setPcellParams ((device PcellParam) cv)
  (when (and cv (dbIsId cv))
    (setSlotValue device 'cvId cv)
    (foreach param cv~>parameters~>value
      (setParamValue device (concat param~>name) param~>value))))

; A function to define a Pcell parameter stored as a Pcell class' slot.
; The optional argument _isParam is set to 't to indicate this parameter is
; a Pcell parameter
(defun defineParam (g_type g_value @optional (_isParam t))
  (list nil 'type g_type 'value g_value 'isParam _isParam))

; A method to get Pcell parameter's type
(defmethod getParamType ((device PcellParam) (propName symbol))
  ((slotValue device propName)->type))

; A method to get Pcell parameter's value
(defmethod getParamValue ((device PcellParam) (propName symbol))
  (slotValue device propName)->value)

; A method to set Pcell parameter's value
(defmethod setParamValue ((device PcellParam) (propName symbol) val)
  (setSlotValue device (slotValue (slotValue device propName) 'value) val))

(defmethod setParamValue ((device PcellParam) (propName symbol) val)
  ((slotValue device propName)->value = val))

; A method to check is the given name a Pcell parameter or not. This is
; based on the setting of the isParam attribute
(defmethod isParam ((device PcellParam) (propName symbol))
  (slotValue device propName)->isParam)

; A method to get a list of Pcell parameters with their names, types and
; values
(defmethod getPcellParams ((device PcellParam))
  (let ((params nil))
    (setq params (setof p device->? (isParam device p)))
    (setq params (foreach mapcar p params
                   (list p (getParamType device p) (getParamValue device p))))))
