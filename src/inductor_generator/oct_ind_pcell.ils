(defclass qub::octInductorPCell (qub::inductorPCell) ())

(defmethod qub::draw ((device qub::octInductorPCell))
  (qub::setParamValue device 'nsides 8)
  (callNextMethod))

(defmacro qub::createOctInductorPCell (@key (library nil)
                                            (defaultMetalLayer nil))
  `(pcDefinePCell
    (list (ddGetObj ,library) "octSpiralInd" "layout")
    ((completeTurns "int" 2)
     (additionalSegments "int" 0)
     (width "float" 10.0)
     (spacing "float" 5.0)
     (apothem "float" 50.0)
     (metalLayer "string" ,defaultMetalLayer))
    (let ((pcell (makeInstance 'qub::octInductorPCell)))
      (qub::setPcellParams pcell pcCellView)
      (qub::draw pcell))))
