(defclass inductorPCell (PcellParam)
  ((completeTurns @initform (defineParam "int" 2))
   (additionalSegments @initform (defineParam "int" 0))
   (width @initform (defineParam "float" 10.0))
   (spacing @initform (defineParam "float" 5.0))
   (apothem @initform (defineParam "float" 50.0))
   (nsides @initform (defineParam "int" 8))
   (rotation_anticlockwise @initform (defineParam "float" 0.0))
   (metalLayer @initform (defineParam "string" "M1"))))

(defmethod draw ((device inductorPCell))
  (let ((ct (getParamValue device 'completeTurns))
        (as (getParamValue device 'additionalSegments))
        (w (getParamValue device 'width))
        (s (getParamValue device 'spacing))
        (a (getParamValue device 'apothem))
        (n (getParamValue device 'nsides))
        (ml (getParamValue device 'metalLayer))
        (ra (getParamValue device 'rotation_anticlockwise))
        (cv (slotValue device 'cvId)))
    (let ((points (qub::getSpiralPoints ?completeTurns ct
                                        ?additionalSegments as
                                        ?width w
                                        ?spacing s
                                        ?apothem a
                                        ?nsides n
                                        ?rotation_anticlockwise ra)))
      (dbCreatePath cv (list ml) points w "truncateExtend"))
      (callNextMethod)))

(defmacro qub::createInductorPCell (library)
  `(pcDefinePCell
    (list (ddGetObj ,library) "spiralInductorPCell" "layout")
    ((completeTurns "int" 2)
     (additionalSegments "int" 0)
     (width "float" 10.0)
     (spacing "float" 5.0)
     (apothem "float" 50.0)
     (nsides "int" 8)
     (metalLayer "string" "M1")
     (rotation_anticlockwise "float" 0.0))
    (let ((pcell (makeInstance 'inductorPCell)))
      (setPcellParams pcell pcCellView)
      (draw pcell))))

;(qub::createInductorPCell "mlove_lib" "indPCell")
