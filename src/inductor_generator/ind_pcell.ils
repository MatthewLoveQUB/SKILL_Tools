(defclass qub::inductorPCell (qub::PcellParam)
  ((completeTurns @initform (qub::defineParam "int" 2))
   (additionalSegments @initform (qub::defineParam "int" 0))
   (width @initform (qub::defineParam "float" 10.0))
   (spacing @initform (qub::defineParam "float" 2.0))
   (apothem @initform (qub::defineParam "float" 50.0))
   (nsides @initform (qub::defineParam "int" 8))
   (metalLayer @initform (qub::defineParam "string" "M1"))))

(defmethod qub::draw ((device qub::inductorPCell))
  (let ((ct (qub::getParamValue device 'completeTurns))
        (as (qub::getParamValue device 'additionalSegments))
        (w (qub::getParamValue device 'width))
        (s (qub::getParamValue device 'spacing))
        (a (qub::getParamValue device 'apothem))
        (n (qub::getParamValue device 'nsides))
        (ml (qub::getParamValue device 'metalLayer))
        (cv (slotValue device 'cvId)))
    (let ((points (qub::getSpiralPoints ?completeTurns ct
                                        ?additionalSegments as
                                        ?width w
                                        ?spacing s
                                        ?apothem a
                                        ?nsides n
                                        ?rotation_anticlockwise 0.0)))
      (dbCreatePath cv (list ml) points w "truncateExtend"))
      (callNextMethod)))

(defmacro qub::createInductorPCell (@key (library nil)
                                         (defaultMetalLayer nil))
  (letseq ((cellName "spiralInd")
           (cellType "layout")
           (cellObj (ddGetObj library cellName)))
    ; Delete the cell if it doesn't exist
    ; As re-running the macro doesn't seem to refresh the PCell instance
    (if cellObj
        (ddDeleteObj cellObj))
    `(pcDefinePCell
      (list (ddGetObj ,library) ,cellName ,cellType)
      ((completeTurns "int" 2)
       (additionalSegments "int" 0)
       (width "float" 10.0)
       (spacing "float" 5.0)
       (apothem "float" 50.0)
       (nsides "int" 8)
       (metalLayer "string" ,defaultMetalLayer))
      (let ((pcell (makeInstance 'qub::inductorPCell)))
        (qub::setPcellParams pcell pcCellView)
        (qub::draw pcell)))))
