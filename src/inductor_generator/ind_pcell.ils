; Defines the generic function for draw.
; This is placed in its own file as this should be loaded
; once as redefining a generic function will
(defgeneric draw (device) t)

; Base class for all Pcells.
; cvId will hold the pcCellView value
(defclass PcellParam ()
  ((cvId @initarg cvId)))

; A simple method to populate the Pcell parameters from the super master to
; a Pcell device's slots
(defmethod setPcellParams ((device PcellParam) cv)
  (when (and cv (dbIsId cv))
    (setSlotValue device 'cvId cv)
    (foreach param cv~>parameters~>value
      (setParamValue device (concat param~>name) param~>value))))

; A function to define a Pcell parameter stored as a Pcell class' slot.
; The optional argument _isParam is set to 't to indicate this parameter is
; a Pcell parameter
(defun defineParam (g_type g_value @optional (_isParam t))
  (list nil 'type g_type 'value g_value 'isParam _isParam))

; A method to get Pcell parameter's type
(defmethod getParamType ((device PcellParam) (propName symbol))
  ((slotValue device propName)->type))

; A method to get Pcell parameter's value
(defmethod getParamValue ((device PcellParam) (propName symbol))
  (slotValue device propName)->value)

; A method to set Pcell parameter's value
(defmethod setParamValue ((device PcellParam) (propName symbol) val)
  (setSlotValue device (slotValue (slotValue device propName) 'value) val))

(defmethod setParamValue ((device PcellParam) (propName symbol) val)
  ((slotValue device propName)->value = val))

; A method to check is the given name a Pcell parameter or not. This is
; based on the setting of the isParam attribute
(defmethod isParam ((device PcellParam) (propName symbol))
  (slotValue device propName)->isParam)

; A method to get a list of Pcell parameters with their names, types and
; values
(defmethod getPcellParams ((device PcellParam))
  (let ((params nil))
    (setq params (setof p device->? (isParam device p)))
    (setq params (foreach mapcar p params
                   (list p (getParamType device p) (getParamValue device p))))))

(defclass inductorPCell (PcellParam)
  ((completeTurns @initform (defineParam "int" 2))
   (additionalSegments @initform (defineParam "int" 0))
   (width @initform (defineParam "float" 10.0))
   (spacing @initform (defineParam "float" 5.0))
   (apothem @initform (defineParam "float" 50.0))
   (nsides @initform (defineParam "int" 8))
   (rotation_anticlockwise @initform (defineParam "float" 0.0))
   (metalLayer @initform (defineParam "string" "M1"))))

(defmethod draw ((device inductorPCell))
  (let ((ct (getParamValue device 'completeTurns))
        (as (getParamValue device 'additionalSegments))
        (w (getParamValue device 'width))
        (s (getParamValue device 'spacing))
        (a (getParamValue device 'apothem))
        (n (getParamValue device 'nsides))
        (ml (getParamValue device 'metalLayer))
        (ra (getParamValue device 'rotation_anticlockwise))
        (cv (slotValue device 'cvId)))
    (let ((points (qub::getSpiralPoints ?completeTurns ct
                                        ?additionalSegments as
                                        ?width w
                                        ?spacing s
                                        ?apothem a
                                        ?nsides n
                                        ?rotation_anticlockwise ra)))
      (dbCreatePath cv (list ml) points w "truncateExtend"))
      (callNextMethod)))

(defun qub::createInductorPCell (library cellName)
  (pcDefinePCell
    (list (ddGetObj library) cellName "layout")
    ((completeTurns "int" 2)
     (additionalSegments "int" 0)
     (width "float" 10.0)
     (spacing "float" 5.0)
     (apothem "float" 50.0)
     (nsides "int" 8)
     (metalLayer "string" "M1")
     (rotation_anticlockwise "float" 0.0))
    (let ((pcell (makeInstance 'inductorPCell)))
      (setPcellParams pcell pcCellView)
      (draw pcell))))
