(defclass qub::symmInductorPCell (qub::PcellParam)
  ((turns @initform (qub::defineParam "int" 2))
   (width @initform (qub::defineParam "float" 10.0))
   (underpassWidth @initform (qub::defineParam "underpassWidth" 10.0))
   (spacing @initform (qub::defineParam "float" 5.0))
   (apothem @initform (qub::defineParam "float" 50.0))
   (nsides @initform (qub::defineParam "int" 8))
   (metalStack @initform (qub::defineParam "string" "M1 M2"))
   (portLength @initform (qub::defineParam "float" "25.0"))))

(defmethod qub::draw ((device qub::symmInductorPCell))
  (letseq ((w (qub::getParamValue device 'width))
           (underWidth (qub::getParamValue device 'underpassWidth))
           (metalLayers (parseString (qub::getParamValue device 'metalStack)))
           (cv (slotValue device 'cvId))
           (points
             (qub::getSymmetricSpiralPoints
               ?turns (qub::getParamValue device 'turns)
               ?width w
               ?spacing (qub::getParamValue device 'spacing)
               ?apothem (qub::getParamValue device 'apothem)
               ?nsides (qub::getParamValue device 'nsides)
               ?portLen (qub::getParamValue device 'portLength)))
           (objects nil)
           (mode "truncateExtend")
           (cp (lambda (pts metLyr width)
             (pushf (dbCreatePath cv
                                  (list metLyr)
                                  (mapcar qub::roundCoord5nm pts)
                                  width
                                  mode)
                    objects)))
           (drawPts (lambda (pts metal width) (foreach p pts (cp p metal width)))))

      ; Generating main turns
      (foreach turn points->spiralCoords
        (cp turn->left (car metalLayers) w)
        (cp turn->right (car metalLayers) w))

      ; Generating interconnects
      (drawPts points->intercons->topMetal (car metalLayers) w)
      (drawPts points->intercons->botMetal (cadr metalLayers) underWidth)
      (setq objects (leMergeShapes objects))

      (letseq ((metalLayer (list (car metalLayers) "pin"))
               (f (lambda (x n)
                 (leCreatePin cv
                              metalLayer
                              "rectangle"
                              (list (qub::mvPtX x (w / 2))
                                    (qub::movePoint x -(w / 2):w))
                              (sprintf nil "port%d" n)
                              "inputOutput"
                              (list "top" "bottom" "left" "right"))
                (dbCreateLabel cv
                               metalLayer
                               (qub::mvPtY x (w / 2))
                               (sprintf nil "port%d" n)
                               "centerCenter"
                               "R0"
                               "stick"
                               (w / 3)))))
        (f points->ports->left 0)
        (f points->ports->right 1))

      ; Create fig group to organise the parts
      (let ((fg (dbCreateFigGroup cv "IndGroup" t 0.0:0.0 "R0")))
        (mapc (lambda (obj) (dbAddFigToFigGroup fg obj)) objects)
        fg)))

(defmacro qub::createSymmInductorPCell (@key (library nil)
                                             (defaultTopMetalLayer nil)
                                             (defaultTopMinusOneMetalLayer nil))
  (letseq ((cellName "symmInd")
           (cellType "layout")
           (cellObj (ddGetObj library cellName)))
    ; Delete the cell if it doesn't exist
    ; As re-running the macro doesn't seem to refresh the PCell instance
    (if cellObj
        (ddDeleteObj cellObj))
    `(pcDefinePCell
      (list (ddGetObj ,library) ,cellName ,cellType)
      ((turns "int" 2)
       (width "float" 10.0)
       (underpassWidth "float" 10.0)
       (spacing "float" 5.0)
       (apothem "float" 50.0)
       (nsides "int" 8)
       (metalStack "string"
                   (strcat ,defaultTopMetalLayer
                           " "
                           ,defaultTopMinusOneMetalLayer))
       (portLength "float" 25.0))
      (let ((pcell (makeInstance 'qub::symmInductorPCell)))
        (qub::setPcellParams pcell pcCellView)
        (qub::draw pcell)))))
