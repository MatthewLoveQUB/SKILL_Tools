(defclass symmInductorPCell (PcellParam)
  ((turns @initform (defineParam "int" 2))
   (width @initform (defineParam "float" 10.0))
   (spacing @initform (defineParam "float" 5.0))
   (apothem @initform (defineParam "float" 50.0))
   (nsides @initform (defineParam "int" 8))
   (metalStack @initform (defineParam "string" "M1 M2"))))

(defmethod draw ((device symmInductorPCell))
  (letseq ((turns (getParamValue device 'turns))
           (w (getParamValue device 'width))
           (s (getParamValue device 'spacing))
           (a (getParamValue device 'apothem))
           (n (getParamValue device 'nsides))
           (metalLayers (parseString (getParamValue device 'metalStack)))
           (cv (slotValue device 'cvId))
           (points (qub::getSymmetricSpiralPoints ?turns turns
                                                  ?width w
                                                  ?spacing s
                                                  ?apothem a
                                                  ?nsides n
                                                  ?rotation_anticlockwise 45.0))
           (offset 0)
           (spiralCoords (car points))
           (bridgeCoords (cadr points))
           (objects nil)
           (mode "truncateExtend")
           (cp (lambda (pts metLyr)
                 (pushf (dbCreatePath cv (list metLyr) pts w mode) objects))))

    ; Generating main turns
    (foreach turn spiralCoords
      (foreach half turn
        (cp half (car metalLayers))))

    ; Generating interconnects
    (let ((topMetalBridges (car bridgeCoords))
          (bottomMetalBridges (cadr bridgeCoords))
          (drawPts (lambda (pts metal) (foreach p pts (cp p metal)))))
      (drawPts topMetalBridges (car metalLayers))
      (drawPts bottomMetalBridges (cadr metalLayers)))

    (setq objects (leMergeShapes objects))

    ; creating a fig group to organise the parts
    (let ((fg (dbCreateFigGroup cv "IndGroup" t 0.0:0.0 "R0")))
      (mapc (lambda (obj) (dbAddFigToFigGroup fg obj)) objects)
      fg)))

(defmacro qub::createSymmInductorPCell (library)
  `(pcDefinePCell
    (list (ddGetObj ,library) "symmInd" "layout")
    ((turns "int" 2)
     (width "float" 10.0)
     (spacing "float" 5.0)
     (apothem "float" 50.0)
     (nsides "int" 8)
     (metalStack "string" "M1 M2"))
    (let ((pcell (makeInstance 'symmInductorPCell)))
      (setPcellParams pcell pcCellView)
      (draw pcell))))
