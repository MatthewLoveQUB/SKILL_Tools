(defclass symmInductorPCell (PcellParam)
  ((turns @initform (defineParam "int" 2))
   (width @initform (defineParam "float" 10.0))
   (spacing @initform (defineParam "float" 5.0))
   (apothem @initform (defineParam "float" 50.0))
   (nsides @initform (defineParam "int" 8))
   (topMetalLayer @initform (defineParam "string" "M1"))
   (bottomMetalLayer @initform (defineParam "string" "M2"))))

(defmethod draw ((device symmInductorPCell))
  (letseq ((turns (getParamValue device 'turns))
           (w (getParamValue device 'width))
           (s (getParamValue device 'spacing))
           (a (getParamValue device 'apothem))
           (n (getParamValue device 'nsides))
           (tml (getParamValue device 'topMetalLayer))
           (bml (getParamValue device 'bottomMetalLayer))
           (cv (slotValue device 'cvId))
           (points (qub::getSymmetricSpiralPoints ?turns turns
                                                  ?width w
                                                  ?spacing s
                                                  ?apothem a
                                                  ?nsides n
                                                  ?rotation_anticlockwise 45.0))
           (offset 0)
           (spiralCoords (car points))
           (bridgeCoords (cadr points))
           (objects nil)
           (mode "truncateExtend")
           (cp (lambda (pts metLyr)
                 (pushf (dbCreatePath cv (list metLyr) pts w mode) objects))))

    ; Generating main turns
    (foreach turn spiralCoords
      (foreach half turn
        (cp half tml)))

    ; Generating interconnects
    (let ((topMetalBridges (car bridgeCoords))
          (bottomMetalBridges (cadr bridgeCoords))
          (drawPts (lambda (pts metal) (foreach p pts (cp p metal)))))
      (drawPts topMetalBridges tml)
      (drawPts bottomMetalBridges bml))

    ;(setq objects (leMergeShapes objects))

    ; creating a fig group to organise the parts
    (let ((fg (dbCreateFigGroup cv "IndGroup" t 0.0:0.0 "R0")))
      (mapc (lambda (obj) (dbAddFigToFigGroup fg obj)) objects)
      fg)))

(defmacro qub::createSymmInductorPCell (library)
  `(pcDefinePCell
    (list (ddGetObj ,library) "symmetricInductorPCell" "layout")
    ((turns "int" 2)
     (width "float" 10.0)
     (spacing "float" 5.0)
     (apothem "float" 50.0)
     (nsides "int" 8)
     (topMetalLayer "string" "M1")
     (bottomMetalLayer "string" "M2"))
    (let ((pcell (makeInstance 'symmInductorPCell)))
      (setPcellParams pcell pcCellView)
      (draw pcell))))

; (qub::createSymmInductorPCell "mlove_lib" "symmIndPCell")
