(defclass qub::symmInductorPCell (qub::PcellParam)
  ((turns @initform (qub::defineParam "int" 2))
   (width @initform (qub::defineParam "float" 10.0))
   (spacing @initform (qub::defineParam "float" 5.0))
   (apothem @initform (qub::defineParam "float" 50.0))
   (nsides @initform (qub::defineParam "int" 8))
   (metalStack @initform (qub::defineParam "string" "M1 M2"))))

(defmethod qub::draw ((device qub::symmInductorPCell))
  (letseq ((turns (qub::getParamValue device 'turns))
           (w (qub::getParamValue device 'width))
           (s (qub::getParamValue device 'spacing))
           (a (qub::getParamValue device 'apothem))
           (n (qub::getParamValue device 'nsides))
           (metalLayers (parseString (qub::getParamValue device 'metalStack)))
           (cv (slotValue device 'cvId))
           (points (qub::getSymmetricSpiralPoints ?turns turns
                                                  ?width w
                                                  ?spacing s
                                                  ?apothem a
                                                  ?nsides n
                                                  ?rotation_anticlockwise 45.0))
           (offset 0)
           (spiralCoords (car points))
           (bridgeCoords (cadr points))
           (objects nil)
           (mode "truncateExtend")
           (cp (lambda (pts metLyr)
                 (pushf (dbCreatePath cv (list metLyr) pts w mode) objects))))

    ; Generating main turns
    (foreach turn spiralCoords
      (cp turn->left (car metalLayers))
      (cp turn->right (car metalLayers)))

    ; Generating interconnects
    (let ((topMetalBridges bridgeCoords->topMetal)
          (bottomMetalBridges bridgeCoords->botMetal)
          (drawPts (lambda (pts metal) (foreach p pts (cp p metal)))))
      (drawPts topMetalBridges (car metalLayers))
      (drawPts bottomMetalBridges (cadr metalLayers)))

    (setq objects (leMergeShapes objects))

    ; creating a fig group to organise the parts
    (let ((fg (dbCreateFigGroup cv "IndGroup" t 0.0:0.0 "R0")))
      (mapc (lambda (obj) (dbAddFigToFigGroup fg obj)) objects)
      fg)))

(defmacro qub::createSymmInductorPCell (library)
  `(pcDefinePCell
    (list (ddGetObj ,library) "symmInd" "layout")
    ((turns "int" 2)
     (width "float" 10.0)
     (spacing "float" 5.0)
     (apothem "float" 50.0)
     (nsides "int" 8)
     (metalStack "string" "M1 M2"))
    (let ((pcell (makeInstance 'qub::symmInductorPCell)))
      (qub::setPcellParams pcell pcCellView)
      (qub::draw pcell))))
