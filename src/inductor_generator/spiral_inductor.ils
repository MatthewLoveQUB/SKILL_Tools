(defun qub::getSpiralPoints (@key
                             (completeTurns 2)
                             (additionalSegments 0)
                             (width 10.0)
                             (spacing 5.0)
                             (apothem 50.0)
                             (nsides 8)
                             (rotation_anticlockwise 0.0)
                             (ref 0.0:0.0))
  (when (greaterp additionalSegments nsides)
        (error "More additional segments then sides"))
  ; plus width is a hack needed because there is a big with left alignment
  ; right alignment works but needs the apothem increased to compensate
	(let ((circumradius (qub::apothemToCircumradius (plus
                                                    (quotient
                                                      width
                                                      2.0)
                                                    apothem)
                                                  nsides)))
    (let ((points nil)
          (getPoint (lambda (polyIdx pointIdx)
                      (qub::getPolyPoint polyIdx
                                         pointIdx
                                         nsides
                                         circumradius
                                         spacing
                                         width
                                         ?rotation_anticlockwise
                                           rotation_anticlockwise
                                         ?ref ref)))
          (maxTurnIdx (if (zerop additionalSegments)
                          (sub1 completeTurns)
                          completeTurns))
          (maxPointIdx (sub1 nsides)))
      (for turnIdx 0 maxTurnIdx
        ; drawing each segment
        (let ((maxPointIdx (if (and (equal turnIdx maxTurnIdx)
                                    (not (zerop additionalSegments)))
                               (sub1 additionalSegments)
                               maxPointIdx)))
          (for pointIdx 0 maxPointIdx
            (pushf (getPoint turnIdx pointIdx) points)))
        (unless (equal turnIdx maxTurnIdx)
          ; Adding the bridging point to the next spiral
          (let ((fip qub:::findIntersectPoint)
                (refa1 (getPoint turnIdx (sub1 maxPointIdx)))
                (refa2 (getPoint turnIdx maxPointIdx))
                ; Get the first and last points of the next spiral
                ; So we can find the collinear point that intersects them
                (refb1 (getPoint (add1 turnIdx) 0))
                (refb2 (getPoint (add1 turnIdx) maxPointIdx)))
           (pushf (fip refa1 refa2 refb1 refb2) points))))
      (qub:::truncateFirstLastPoints (reverse points)))))

(defun qub:::truncateFirstLastPoints (lst)
  (let ((midPoint (lambda (a b)
                    (range
                      (quotient (plus (xCoord b) (xCoord a)) 2.0)
                      (quotient (plus (yCoord b) (yCoord a)) 2.0)))))
    (rplaca lst (midPoint (car lst) (cadr lst)))
    (let ((rLst (reverse lst)))
      (rplaca rLst (midPoint (car rLst) (cadr rLst)))
      (reverse rLst))))

(defun qub::drawInductor (@key
                           (completeTurns 2)
                           (additionalSegments 0)
                           (width 10.0)
                           (spacing 5.0)
                           (apothem 50.0)
                           (nsides 8)
                           (metalLayer "M1")
                           (rotation_anticlockwise 0.0)
                           (ref 0.0:0.0))
  (let ((points (qub::getSpiralPoints ?completeTurns completeTurns
                                      ?additionalSegments additionalSegments
                                      ?width width
                                      ?spacing spacing
                                      ?apothem apothem
                                      ?nsides nsides
                                      ?rotation_anticlockwise
                                        rotation_anticlockwise
                                      ?ref ref))
        (offset 0))
    (leCreatePath (geGetEditCellView)
                  (list metalLayer)
                  points
                  width
                  "truncateExtend"
                  offset
                  "center")))
