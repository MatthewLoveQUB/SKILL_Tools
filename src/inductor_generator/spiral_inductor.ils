(defun qub::getSpiralPoints (@key
                             (completeTurns 2)
                             (additionalSegments 0)
                             (width 10.0)
                             (spacing 5.0)
                             (apothem 50.0)
                             (nsides 8)
                             (rotation_anticlockwise 0.0)
                             (ref 0.0:0.0))
  (when (greaterp additionalSegments nsides)
        (error "More additional segments then sides"))
  (let ((a2c qub::apothemToCircumradius)
        (fip qub:::findIntersectPoint)
        (maxTurnIdx (if (zerop additionalSegments)
                          (sub1 completeTurns)
                          completeTurns))
        (maxPointIdx (sub1 nsides)))
    (let ((points nil)
          (getPoint
            (lambda (polyIdx pointIdx)
              (qub::getPolyPoint
                polyIdx
                pointIdx
                nsides
                (a2c ((width / 2.0) + apothem) nsides)
                spacing
                width
                ?rotation_anticlockwise rotation_anticlockwise
                ?ref ref)))
          (getMaxPtIdx
            (lambda (trnIdx)
              (if (and (equal trnIdx maxTurnIdx) (plusp additionalSegments))
                  (sub1 additionalSegments)
                  maxPointIdx))))
      (for turnIdx 0 maxTurnIdx
        ; drawing each segment
        (for pointIdx 0 (getMaxPtIdx turnIdx)
            (pushf (getPoint turnIdx pointIdx) points))
        (unless (equal turnIdx maxTurnIdx)
          ; Get the last two points of the current spiral
          ; and the first two points of the next spiral
          ; and calculate an intersection point to bridge
          ; the two spirals together
          (let ((cur1 (getPoint turnIdx (sub1 maxPointIdx)))
                (cur2 (getPoint turnIdx maxPointIdx))
                (nxt1 (getPoint (add1 turnIdx) 0))
                (nxt2 (getPoint (add1 turnIdx) maxPointIdx)))
           (pushf (fip cur1 cur2 nxt1 nxt2) points))))
    points)))
