; Create one of the sub-coils of a Frlan coil

; Convert a list of octagons into a frlan coil
; Args:
;   shapes: (list (list (list float float)))
;           A list of octagon shapes
;           Each octagon is a list of floating point co-ordinate pairs
;   nSegs: integer
;          The number of segments to be joined together
; Returns:
;   List of co-ordinates of the coil
(defun qub::octagonsToFrlan (shapes nSegs)
  (letseq (; Join the shapes into a single list
           (inList (qub::joinLists shapes))
           ; Create the output list with the first point added
           (outList (list (nth 0 inList)))
           ; A counter for the required segments
           (segCount 0)
           ; Index for the current segment
           (segIndex 1))
    ; Loop until we have all of the points
    (while (neq segCount nSegs)
      (cond
        ; If we're moving to the next shape
        ; e.g. index 8 would be the first coordinate of the new shape
        ; then make a bridge and move to the next shape.
        ((zerop (mod segIndex 8))
         (letseq ((lastPoint (nth (segIndex-1) inList))
                  (secondLastPoint (nth (segIndex-2) inList))
                  (thisPoint (nth segIndex inList))
                  (nextPoint (nth (segIndex+7) inList))
                  (bridgePoint (qub::findIntersectPoint lastPoint
                                                        secondLastPoint
                                                        thisPoint
                                                        nextPoint)))
           ; Add the bridge point
           (qub::pushEnd bridgePoint outList)
           ; Add the new point
           (qub::pushEnd thisPoint outList)
           ; Increment the counts
           (setq segCount (segCount + 1))
           (setq segIndex (segIndex + 1))))
        ; If we're at the top right of the shape
        ; e.g. index 3
        ; then move to the next shape.
        ((eq 4 (mod segIndex 8))
         (letseq ((lastPoint (nth (segIndex-1) inList))
                  (secondLastPoint (nth (segIndex-2) inList))
                  (thisPoint (nth (segIndex+7) inList))
                  (nextPoint (nth (segIndex+8) inList))
                  (bridgePoint (qub::findIntersectPoint lastPoint
                                                        secondLastPoint
                                                        thisPoint
                                                        nextPoint)))
           ; Add the bridge point
           (qub::pushEnd bridgePoint outList)
           ; Add the new point
           (qub::pushEnd nextPoint outList)
           ; Increment the counts
           (setq segCount (segCount + 1))
           (setq segIndex (segIndex + 9))))
        ; Otherwise just add the new coordinate and increment the counts
        (t
         (progn (qub::pushEnd (nth segIndex inList) outList)
                (setq segCount (segCount + 1))
                (setq segIndex (segIndex + 1))))))
    outList))

(defclass qub::frlanSegmentPCell (qub::PcellParam)
  ((width @initform (qub::defineParam "float" 15.0))
   (spacing @initform (qub::defineParam "float" 2.0))
   (apothem @initform (qub::defineParam "float" 30.0))
   (turns @initform (qub::defineParam "float" 3.0))
   (metalLayer @initform (qub::defineParam "string" "AP"))
   (drawnWidth @initform (qub::defineParam "float" 15.0))))

(defmethod qub::draw ((device qub::frlanSegmentPCell))
  (letseq ((width (qub::getParamValue device 'width))
           (spacing (qub::getParamValue device 'spacing))
           (apothem (qub::getParamValue device 'apothem))
           (turns (qub::getParamValue device 'turns))
           (metalLayer (qub::getParamValue device 'metalLayer))
           (drawnWidth (qub::getParamValue device 'drawnWidth))
           ; Metal Layer Purpose Pair
           (layerPP (list metalLayer "drawing"))
           ; Number of shapes to be generated
           (nShapes ((turns * 2) + 1))
           ; List of octagon shapes
           (octagons (qub::genOctagons width spacing apothem nShapes))
           ; Length of a segment relative to the turn
           (segLen (quotient 1.0 8.0))
           ; Number of segments needed
           (nSegs (floor (quotient turns segLen)))
           ; Process the coordinates into a coil
           ; We add an extra segment so we can have a good spot
           ; for the IO pins
           (coords (qub::octagonsToFrlan octagons (1+nSegs)))
           ; Get the last two points (we added an extra one)
           ; and find the midpoint of the two of them
           ; Then set the last point as the midpoint
           (nCoords (length coords))
           (lastPoint (nth (nCoords-1) coords))
           (secondLastPoint (nth (nCoords-2) coords))
           (midPoint (qub::midPoint lastPoint secondLastPoint))
           ; Get the angle of the final two points
           ; Add 90 degrees for the output section
           (ang (qub::getAngleToPt secondLastPoint lastPoint))
           (newAng (ang + 90.0))
           (finalPoint (qub::moveAtAngle midPoint width newAng))
           ; Get the midpoint of the first two points so it's easy to
           ; connect the insides together
           (firstPoint (nth 0 coords))
           (secondPoint (nth 1 coords))
           (initMidpoint (qub::midPoint firstPoint secondPoint)))
    ; Mutate the final value of the last and change it to the midpoint
    (setf (nth (nCoords-1) coords) midPoint)
    ; Mutate the first value with the midpoint
    (setf (nth 0 coords) initMidpoint)
    ; Add the output point
    (qub::pushEnd finalPoint coords)
    ; Fix the coordinates to a 5nm grid value
    (setf coords (mapcar qub::roundCoord5nm coords))
    ; Draw the coil itself
    (rodCreatePath ?name "path"
                   ?layer layerPP
                   ?width drawnWidth
                   ?pts coords)))

(defmacro qub::createFrlanSegmentPCell (@key (library nil)
                                             (defaultMetalLayer nil))
  (letseq ((cellName "frlanSegment")
           (cellType "layout")
           (cellObj (ddGetObj library cellName)))
    ; Delete the cell if it doesn't exist
    ; As re-running the macro doesn't seem to refresh the PCell instance
    (if cellObj
        (ddDeleteObj cellObj))
    `(pcDefinePCell
      (list (ddGetObj ,library) ,cellName ,cellType)
      ((width "float" 15.0)
       (spacing "float" 2.0)
       (apothem "float" 30.0)
       (turns "float" 3.0)
       (metalLayer "string" ,defaultMetalLayer)
       (drawnWidth "float" 15.0))
      (let ((pcell (makeInstance 'qub::frlanSegmentPCell)))
        (qub::setPcellParams pcell pcCellView)
        (qub::draw pcell)))))
