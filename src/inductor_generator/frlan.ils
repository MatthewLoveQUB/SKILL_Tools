; Creates a Frlan PCell
(defclass qub::frlanPCell (qub::PcellParam)
  ((width @initform (qub::defineParam "float" 15.0))
   (spacing @initform (qub::defineParam "float" 2.0))
   (apothem @initform (qub::defineParam "float" 30.0))
   (turns @initform (qub::defineParam "float" 3.0))
   (metalLayer @initform (qub::defineParam "string" "AP"))))

; Draw the PCell in the layout
; Args:
;  device: qub::frlanPCell
;          The instance the method is acting on
;  pcCellView: cellview object
;              The cellview of the PCell instance
;  segLib: string
;          The library that the frlanSegment PCell resides in
(defmethod qub::draw ((device qub::frlanPCell)
                      @key
                      pcCellView
                      segLib)
  (letseq ((gpv (lambda (valName) (qub::getParamValue device valName)))
           (width (gpv 'width))
           (spacing (gpv 'spacing))
           (apothem (gpv 'apothem))
           (turns (gpv 'turns))
           (metalLayer (gpv 'metalLayer))
           (pathCellId (dbOpenCellViewByType segLib
                                             "frlanSegment"
                                             "layout"))
           (makeLoop
             (lambda
               (rotation instName)
               (dbCreateParamInst
                 pcCellView
                 pathCellId
                 instName
                 0:0
                 rotation
                 1
                 (list (list "width" "float" width)
                       (list "spacing" "float" spacing)
                       (list "apothem" "float" apothem)
                       (list "turns" "float" turns)
                       (list "metalLayer" "string" metalLayer))))))
    (makeLoop "R0" "coil1")
    (makeLoop "R180" "coil2")))

(defmacro qub::createFrlanPCell (@key (library nil)
                                      (defaultMetalLayer nil))
  `(pcDefinePCell
    (list (ddGetObj ,library) "Frlan" "layout")
    ((width "float" 15.0)
     (spacing "float" 2.0)
     (apothem "float" 30.0)
     (turns "float" 3.0)
     (metalLayer "string" ,defaultMetalLayer))
    (let ((pcell (makeInstance 'qub::frlanPCell)))
      (qub::setPcellParams pcell pcCellView)
      (qub::draw pcell
                 ?pcCellView pcCellView
                 ?segLib ,library))))
