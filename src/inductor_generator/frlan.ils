; Creates a Frlan PCell

(defclass qub::frlanPCell (qub::PcellParam)
  ((width @initform (qub::defineParam "float" 15.0))
   (spacing @initform (qub::defineParam "float" 2.0))
   (apothem @initform (qub::defineParam "float" 30.0))
   (turns @initform (qub::defineParam "float" 3.0))
   (metalLayer @initform (qub::defineParam "string" "AP"))))

(defmethod qub::draw ((device qub::frlanPCell)
                      @key
                      pcCellView
                      segLib)
  (letseq ((width (qub::getParamValue device 'width))
           (spacing (qub::getParamValue device 'spacing))
           (apothem (qub::getParamValue device 'apothem))
           (turns (qub::getParamValue device 'turns))
           (metalLayer (qub::getParamValue device 'metalLayer))
           (pathCellId (dbOpenCellViewByType segLib
                                             "frlanSegment"
                                             "layout")))
    (dbCreateParamInst pcCellView
                       pathCellId
                       "coil1"
                       0:0
                       "R0"
                       1
                       (list (list "width" "float" width)
                             (list "spacing" "float" spacing)
                             (list "apothem" "float" apothem)
                             (list "turns" "float" turns)
                             (list "metalLayer" "string" metalLayer)))
    (dbCreateParamInst pcCellView
                       pathCellId
                       "coil2"
                       0:0
                       "R180"
                       1
                       (list (list "width" "float" width)
                             (list "spacing" "float" spacing)
                             (list "apothem" "float" apothem)
                             (list "turns" "float" turns)
                             (list "metalLayer" "string" metalLayer)))))

(defmacro qub::createFrlanPCell (@key (library nil)
                                      (defaultMetalLayer nil))
  `(pcDefinePCell
    (list (ddGetObj ,library) "Frlan" "layout")
    ((width "float" 15.0)
     (spacing "float" 2.0)
     (apothem "float" 30.0)
     (turns "float" 3.0)
     (metalLayer "string" ,defaultMetalLayer))
    (let ((pcell (makeInstance 'qub::frlanPCell)))
      (qub::setPcellParams pcell pcCellView)
      (qub::draw pcell
                 ?pcCellView pcCellView
                 ?segLib ,library))))
