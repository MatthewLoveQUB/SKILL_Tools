; Creates a Frlan PCell
(defclass qub::frlanPCell (qub::PcellParam)
  ((width @initform (qub::defineParam "float" 15.0))
   (spacing @initform (qub::defineParam "float" 2.0))
   (apothem @initform (qub::defineParam "float" 30.0))
   (turns @initform (qub::defineParam "int" 2))
   (topMetalLayer @initform (qub::defineParam "string" "LB"))
   (underpassMetalLayer @initform (qub::defineParam "string" "IB"))
   (drawConnectingBridge @initform (qub::defineParam "boolean" nil))
   (inputConnectorType "string" "None")))

; Draw the PCell in the layout
; Args:
;  device: qub::frlanPCell
;          The instance the method is acting on
;  pcCellView: cellview object
;              The cellview of the PCell instance
;  segLib: string
;          The library that the frlanSegment PCell resides in
(defmethod qub::draw ((device qub::frlanPCell)
                      @key
                      pcCellView
                      segLib)
  (letseq ((gpv (lambda (valName) (qub::getParamValue device valName)))
           (width (gpv 'width))
           (spacing (gpv 'spacing))
           (apothem (gpv 'apothem))
           (turns (gpv 'turns))
           (topMetalLayers (parseString (gpv 'topMetalLayer)))
           (originPoint 0:0)
           (pathCellId (dbOpenCellViewByType segLib
                                             "frlanSegment"
                                             "layout"))
           (makeLoop
             (lambda
               (rotation instName metalLayer)
               (dbCreateParamInst
                 pcCellView
                 pathCellId
                 instName
                 originPoint
                 rotation
                 1
                 (list (list "width" "float" width)
                       (list "spacing" "float" spacing)
                       (list "apothem" "float" apothem)
                       (list "turns" "float" turns)
                       (list "metalLayer" "string" metalLayer)))))

           (coils1 (mapcar (lambda (x) (makeLoop "R0"
                                                 (sprintf nil "coil1_%s" x)
                                                 x))
                           topMetalLayers))
           (coils2 (mapcar (lambda (x) (makeLoop "R180"
                                                 (sprintf nil "coil2_%s" x)
                                                 x))
                           topMetalLayers))
           (innerBridges
             (when (qub::getPcellBoolParamVal device 'drawConnectingBridge)
               (mapcar
                 (lambda (x)
                   (let ((instName (sprintf nil "Frlan Bridge_%s" x)))
                     (qub::createFrlanInnerBridge (car coils1)
                                                  (car coils2)
                                                  originPoint
                                                  x
                                                  width
                                                  instName)))
                 topMetalLayers)))
           (inputConnector
             (qub::createFrlanInputConnector device
                                             (gpv 'underpassMetalLayer)
                                             width
                                             (gpv 'inputConnectorType)
                                             (car coils1)
                                             (car coils2))))

    t))

; Returns nil or the bridge ROD object
; gpv is the "get parameter value" lambda defined in qub::draw
(defun qub::createFrlanInnerBridge (coil1
                                    coil2
                                    originPoint
                                    metalLayer
                                    width
                                    bridgeName)
  (letseq ((coil1Points (car coil1->master->shapes)->points)
           (coil2Points (car coil2->master->shapes)->points)
           (bridgePoint1 (car coil1Points))
           ; PCell points are given for their internal cellview
           ; and not the cellview that they reside in.
           ; We need to rotate the second point by 180 degrees
           ; in order to get the actual point.
           (coil2FirstPoint (car coil2Points))
           (bridgePoint2 (qub::rotatePoint originPoint coil2FirstPoint 180.0))
           (bridgePoints (list bridgePoint1 bridgePoint2))
           (layerPP (list metalLayer "drawing")))
    (rodCreatePath ?name bridgeName
                   ?layer layerPP
                   ?width width
                   ?pts bridgePoints
                   ?endType "variable"
                   ?beginExt (quotient width 2)
                   ?endExt (quotient width 2))))

(defun qub::createFrlanInputConnector (device
                                       metalLayer
                                       width
                                       connType
                                       coil1
                                       coil2)
  (letseq ((bbox (device->cvId->bBox))
           (lowEdge (bottomEdge bbox))
           (pathName "inputConnector")
           (layerPP (list metalLayer "drawing"))
           (createCentreBridge
             (lambda ()
               (let ((bottomPoint 0:(difference lowEdge (times 1.5 width)))
                     ; Should probably not hard-code this
                     (topPoint 0:0))
                     (rodCreatePath ?name pathName
                                    ?layer layerPP
                                    ?width width
                                    ?pts (list topPoint bottomPoint)
                                    ?endType "variable"
                                    ?beginExt (quotient width 2)
                                    ?endExt 0)))))
    ;(break)
    (cond ((equal connType "None") nil)
          ((equal connType "Coil Centre") (createCentreBridge))
          ((equal connType "Coil Centre (Wide)")
           (progn (createCentreBridge)
                  (qub::createFrlanInnerBridge
                    coil1 coil2 0:0 metalLayer width "Bridge Under")))
          ((equal connType "Loop Centre") nil))
    t))

(defun qub::createFrlanCdf (library
                            cellName
                            defaultTopMetalLayer
                            defaultBridgeMetalLayer)
  (letseq ((cellId (ddGetObj ,library ,cellName))
           (cdfId (cdfCreateBaseCellCDF cellId)))
    (cdfCreateParam cdfId
                    ?name "width"
                    ?prompt "Path Width"
                    ?type "float"
                    ?defValue 15.0)
    (cdfCreateParam
      cdfId
      ?name "spacing"
      ?prompt "Spacing"
      ?type "float"
      ?defValue 2.0
      ?description "The space between the paths of adjacent coils")
    (cdfCreateParam cdfId
                    ?name "apothem"
                    ?prompt "Inner Diameter"
                    ?type "float"
                    ?defValue 30.0)
    (cdfCreateParam cdfId
                    ?name "turns"
                    ?prompt "Turns"
                    ?type "int"
                    ?defValue 2)
    (cdfCreateParam cdfId
                    ?name "topMetalLayer"
                    ?prompt "Top Metal Layer"
                    ?type "string"
                    ?defValue defaultTopMetalLayer)
    (cdfCreateParam cdfId
                    ?name "underpassMetalLayer"
                    ?prompt "Underpass Metal Layer"
                    ?type "string"
                    ?defValue defaultBridgeMetalLayer)
    (cdfCreateParam cdfId
                    ?name "drawConnectingBridge"
                    ?prompt "Connect inner."
                    ?type "boolean"
                    ?defValue nil
                    ?description "Connect the inner ends of both loops")
    (cdfCreateParam cdfId
                    ?name "inputConnectorType"
                    ?prompt "Add input bridge"
                    ?type "cyclic"
                    ?choices (list "None"
                                   "Coil Centre"
                                   "Coil Centre (Wide)"
                                   "Loop Centre")
                    ?defValue "None"
                    ?description "Connect the inner ends of both loops")))

(defmacro qub::createFrlanPCell (@key (library nil)
                                      (defaultTopMetalLayer nil)
                                      (defaultBridgeMetalLayer nil))
  (letseq ((cellName "Frlan")
           (cellType "layout")
           (cellObj (ddGetObj library cellName)))
    ; Delete the cell if it doesn't exist
    ; As re-running the macro doesn't seem to refresh the PCell instance
    (if cellObj
        (ddDeleteObj cellObj))
    `(progn (pcDefinePCell
               (list (ddGetObj ,library) ,cellName ,cellType)
               ((width "float" 15.0)
                (spacing "float" 2.0)
                (apothem "float" 30.0)
                (turns "int" 2)
                (topMetalLayer "string" ,defaultTopMetalLayer)
                (underpassMetalLayer "string" ,defaultBridgeMetalLayer)
                (drawConnectingBridge "boolean" nil)
                (inputConnectorType "string" "None"))
               (let ((pcell (makeInstance 'qub::frlanPCell)))
                 (qub::setPcellParams pcell pcCellView)
                 (qub::draw pcell
                            ?pcCellView pcCellView
                            ?segLib ,library)))
            (qub::createFrlanCdf ,library
                                 ,cellName
                                 ,defaultTopMetalLayer
                                 ,defaultBridgeMetalLayer))))
