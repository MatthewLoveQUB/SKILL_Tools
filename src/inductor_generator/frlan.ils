; Creates a Frlan PCell
(defclass qub::frlanPCell (qub::PcellParam)
  ((width @initform (qub::defineParam "float" 15.0))
   (spacing @initform (qub::defineParam "float" 2.0))
   (apothem @initform (qub::defineParam "float" 30.0))
   (turns @initform (qub::defineParam "float" 2.0))
   (topMetalLayers @initform (qub::defineParam "string" "LB"))
   (underpassMetalLayers @initform (qub::defineParam "string" "IB"))
   (drawConnectingBridge @initform (qub::defineParam "boolean" nil))
   (inputConnectorType @initform (qub::defineParam "string" "None"))
   (drawSecondInput @initform (qub::defineParam "boolean" nil))))

; Draw the PCell in the layout
; Args:
;  device: qub::frlanPCell
;          The instance the method is acting on
;  pcCellView: cellview object
;              The cellview of the PCell instance
;  segLib: string
;          The library that the frlanSegment PCell resides in
(defmethod qub::draw ((device qub::frlanPCell)
                      @key
                      pcCellView
                      segLib)
  (letseq ((libObj (ddGetObj segLib))
           (tf (techGetTechFile libObj))
           (gpv (lambda (valName) (qub::getParamValue device valName)))
           (width (gpv 'width))
           (limitWidth (lambda (layer) (qub::limitPathWidth tf width layer)))
           (topMetalLayers (parseString (gpv 'topMetalLayers)))
           (underpassMetalLayers (parseString (gpv 'underpassMetalLayers)))
           (origin 0:0)
           (pathCellId
             (dbOpenCellViewByType segLib "frlanSegment" "layout"))
           (makeLoop
             (lambda (rotation instName metalLayer)
               (letseq ((newWidth (limitWidth metalLayer))
                        (params (list (list "width" "float" width)
                                     (list "spacing" "float" (gpv 'spacing))
                                     (list "apothem" "float" (gpv 'apothem))
                                     (list "turns" "float" (gpv 'turns))
                                     (list "metalLayer" "string" metalLayer)
                                     (list "drawnWidth" "float" newWidth))))
                 (dbCreateParamInst
                   pcCellView pathCellId instName origin rotation 1 params))))
           (mkCoil (lambda (rot idx metal)
                     (makeLoop rot (sprintf nil "coil%d_%s" idx metal) metal)))
           (coils1 (mapcar (lambda (x) (mkCoil "R0" 1 x)) topMetalLayers))
           (coils2 (mapcar (lambda (x) (mkCoil "R180" 2 x)) topMetalLayers))
           (coil1 (car coils1))
           (coil2 (car coils2))
           (mkBridge
             (lambda (metLayer)
               (let ((instName (sprintf nil "Frlan Bridge_%s" metLayer)))
                 (qub::createFrlanInnerBridge coil1
                                              coil2
                                              origin
                                              metLayer
                                              (limitWidth metLayer)
                                              instName))))
           (drawInnerBridge
             (qub::getPcellBoolParamVal device 'drawConnectingBridge))
           (innerBridges (when drawInnerBridge
             (mapcar mkBridge topMetalLayers)))
           (bbox (device->cvId->bBox))
           (lowEdge (bottomEdge bbox))
           (inConnType (gpv 'inputConnectorType))
           (mkInConn (lambda (metLayer nameId rotation)
                       (qub::createFrlanInputConnector lowEdge
                                                       metLayer
                                                       (limitWidth metLayer)
                                                       inConnType
                                                       coil1
                                                       coil2
                                                       origin
                                                       nameId
                                                       rotation)))
           (inputConnector
             (mapcar (lambda (x) (mkInConn x "A" 0.0)) underpassMetalLayers))
           (inputConnector2
             (when (qub::getPcellBoolParamVal device 'drawSecondInput)
               (mapcar (lambda (x) (mkInConn x "B" 180.0))
                        underpassMetalLayers))))
    t))

; Returns nil or the bridge ROD object
; gpv is the "get parameter value" lambda defined in qub::draw
(defun qub::createFrlanInnerBridge (coil1
                                    coil2
                                    origin
                                    metalLayer
                                    width
                                    bridgeName)
  (letseq ((coil1Points (car coil1->master->shapes)->points)
           (coil2Points (car coil2->master->shapes)->points)
           (bridgePoint1 (car coil1Points))
           ; PCell points are given for their internal cellview
           ; and not the cellview that they reside in.
           ; We need to rotate the second point by 180 degrees
           ; in order to get the actual point.
           (coil2FirstPoint (car coil2Points))
           (bridgePoint2 (qub::rotatePoint origin coil2FirstPoint 180.0))
           (bridgePoints (list bridgePoint1 bridgePoint2))
           (layerPP (list metalLayer "drawing")))
    (rodCreatePath ?name bridgeName
                   ?layer layerPP
                   ?width width
                   ?pts bridgePoints
                   ?endType "variable"
                   ?beginExt (quotient width 2)
                   ?endExt (quotient width 2))))

(defun qub::createFrlanInputConnector (lowEdge
                                       metalLayer
                                       width
                                       connType
                                       coil1
                                       coil2
                                       origin
                                       nameId
                                       rotation)
  (letseq ((pathName (sprintf nil "inputConnector_%s_%s" nameId metalLayer))
           (layerPP (list metalLayer "drawing"))
           (bottomY (difference lowEdge (times 1.5 width)))
           (createCentreBridge
             (lambda (x) (letseq ((pt1 x:0)
                                  (pt2 x:bottomY)
                                  (pts (list pt1
                                             (if rotation
                                                 (qub::rotatePoint pt1
                                                                   pt2
                                                                   rotation)
                                                 pt2))))
                           (rodCreatePath ?name pathName
                                          ?layer layerPP
                                          ?width width
                                          ?pts pts
                                          ?endType "variable"
                                          ?beginExt (quotient width 2)
                                          ?endExt 0)))))
    (cond ((equal connType "None") nil)
          ((equal connType "Coil Centre") (createCentreBridge 0))
          ((equal connType "Coil Centre (Wide)")
           (let ((underpassName (sprintf nil "Bridge Under %s" metalLayer)))
             (createCentreBridge 0)
             (qub::createFrlanInnerBridge
               coil1 coil2 0:0 metalLayer width underpassName)))
          ((equal connType "Loop Centre")
           (letseq ((rot (lambda (x)
                           (qub::rotatePoint origin x (plus 180.0 rotation))))
                    (coilPoints (car coil2->master->shapes)->points)
                    (pt1 (rot (nth 2 coilPoints)))
                    (pt2 (rot (nth 3 coilPoints)))
                    (xVal (qub::mean (xCoord pt2) (xCoord pt1))))
            (createCentreBridge xVal))))))

(defun qub::createFrlanCdf (library
                            cellName
                            defaultTopMetalLayer
                            defaultBridgeMetalLayer)
  (letseq ((cellId (ddGetObj ,library ,cellName))
           (cdfId (cdfCreateBaseCellCDF cellId)))
    (cdfCreateParam cdfId
                    ?name "width"
                    ?prompt "Path Width"
                    ?type "float"
                    ?defValue 15.0)
    (cdfCreateParam
      cdfId
      ?name "spacing"
      ?prompt "Spacing"
      ?type "float"
      ?defValue 2.0
      ?description "The space between the paths of adjacent coils")
    (cdfCreateParam cdfId
                    ?name "apothem"
                    ?prompt "Inner Diameter"
                    ?type "float"
                    ?defValue 30.0)
    (cdfCreateParam cdfId
                    ?name "turns"
                    ?prompt "Turns"
                    ?type "float"
                    ?defValue 2.0)
    (cdfCreateParam cdfId
                    ?name "topMetalLayers"
                    ?prompt "Top Metal Layer(s)"
                    ?type "string"
                    ?defValue defaultTopMetalLayer)
    (cdfCreateParam cdfId
                    ?name "underpassMetalLayers"
                    ?prompt "Underpass Metal Layer(s)"
                    ?type "string"
                    ?defValue defaultBridgeMetalLayer)
    (cdfCreateParam cdfId
                    ?name "drawConnectingBridge"
                    ?prompt "Connect inner."
                    ?type "boolean"
                    ?defValue nil
                    ?description "Connect the inner ends of both loops")
    (cdfCreateParam cdfId
                    ?name "inputConnectorType"
                    ?prompt "Add input bridge"
                    ?type "cyclic"
                    ?choices (list "None"
                                   "Coil Centre"
                                   "Coil Centre (Wide)"
                                   "Loop Centre")
                    ?defValue "None"
                    ?description "Connect the inner ends of both loops")
    (cdfCreateParam cdfId
                    ?name "drawSecondInput"
                    ?prompt "Add second input"
                    ?type "boolean"
                    ?defValue nil
                    ?description "Add a second input bridge for symmetry.")
    (cdfSaveCDF cdfId)))

(defmacro qub::createFrlanPCell (@key (library nil)
                                      (defaultTopMetalLayer nil)
                                      (defaultBridgeMetalLayer nil))
  (letseq ((cellName "Frlan")
           (cellType "layout")
           (cellObj (ddGetObj library cellName)))
    ; Delete the cell if it doesn't exist
    ; As re-running the macro doesn't seem to refresh the PCell instance
    (if cellObj
        (ddDeleteObj cellObj))
    `(progn (pcDefinePCell
               (list (ddGetObj ,library) ,cellName ,cellType)
               ((width "float" 15.0)
                (spacing "float" 2.0)
                (apothem "float" 30.0)
                (turns "float" 2.0)
                (topMetalLayers "string" ,defaultTopMetalLayer)
                (underpassMetalLayers "string" ,defaultBridgeMetalLayer)
                (drawConnectingBridge "boolean" nil)
                (inputConnectorType "string" "None")
                (drawSecondInput "boolean" nil))
               (let ((pcell (makeInstance 'qub::frlanPCell)))
                 (qub::setPcellParams pcell pcCellView)
                 (qub::draw pcell
                            ?pcCellView pcCellView
                            ?segLib ,library)))
            (qub::createFrlanCdf ,library
                                 ,cellName
                                 ,defaultTopMetalLayer
                                 ,defaultBridgeMetalLayer))))
