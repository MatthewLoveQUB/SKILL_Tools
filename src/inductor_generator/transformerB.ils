; Two single turn octagonal inductors on top of each other

(defclass qub::transformerB (qub::transformerA) ())

(defmethod qub::draw ((device qub::transformerB))
  (qub::setParamValue device 'coilSpacing 0)
  (qub::setParamValue device 'secondCoilDirection "up")
  (qub::setParamValue device 'allowOverlap t)
  (qub::setParamValue device 'coilSpacing
    (qub::getParamValue device 'portLength))
  (qub::setParamValue device 'turns 1)
  (qub::setParamValue device 'nsides 8)
  (letseq ((m (parseString (qub::getParamValue device 'metalStack)))
           (m1 (car m))
           (m2 (cadr m))
           (s (sprintf nil "%s %s %s %s" m1 m1 m2 m2)))
    (qub::setParamValue device 'metalStack s))
  (callNextMethod))

(defmacro qub::createTransformerB (@key (library nil)
                                        (defaultTopMetalLayer nil)
                                        (defaultTopMinusOneMetalLayer nil))
  (letseq ((cellName "transformerB")
           (cellType "layout")
           (cellObj (ddGetObj library cellName)))
    ; Delete the cell if it doesn't exist
    ; As re-running the macro doesn't seem to refresh the PCell instance
    (if cellObj
        (ddDeleteObj cellObj))
    `(pcDefinePCell
      (list (ddGetObj ,library) ,cellName ,cellType)
      ((width "float" 10.0)
       (spacing "float" 0.0)
       (apothem "float" 50.0)
       (coilRotation "string" "R0 R180")
       (metalStack "string"
                   (strcat ,defaultTopMetalLayer
                           " "
                           ,defaultTopMinusOneMetalLayer))
       (portLength "float" 25.0))
      (let ((pcell (makeInstance 'qub::transformerB)))
        (qub::setPcellParams pcell pcCellView)
        (qub::draw pcell)))))
