; A two port measurement that uses both the Y and Z parameters of a coupled
; coil to get both its T and Pi representations.
;
;
; Args:
;   f0: float
;       The frequency for the plot markers
;   plotMode: symbol (Either 'all, 'T, or 'Pi)
;   ports: (list integer integer)
;          The indexes of the two ports of the coil
(defun qub::ocnCoupledCoil (@key (f0 nil)
                                 (plotMode 'all)
                                 (ports (list 1 2)))
  f = (qub::sToF)
  w = (times 2 qub::m.PI f)

  port1 = (car ports)
  port2 = (cadr ports)

  ; T Network representation using Z-Parameters.
  ; T network is assumed to be in the following form.
  ;
  ; P1  O---Za-----Zb---O P2
  ;             |
  ;             Zc
  ;             |
  ; Gnd O---------------O Gnd

  Za = (zpm "sp" port1 port1) - (zpm "sp" port1 port2)
  Zb = (zpm "sp" port2 port2) - (zpm "sp" port1 port2)
  Zc = (zpm "sp" port1 port2)

  Ra = (real Za)
  Rb = (real Zb)
  Rc = (real Zc)

  Xa = (imag Za)
  Xb = (imag Zb)
  Xc = (imag Zc)

  Qa = (quotient Xa Ra)
  Qb = (quotient Xb Rb)
  Qc = (quotient Xc Rc)

  ; The branch inductaces
  La = (quotient Xa w)
  Lb = (quotient Xb w)
  Lc = (quotient Xc w)
  delta_L_T = (abs (difference La Lb))
  delta_L_T_increase = (times 100.0 (quotient delta_L_T (min La Lb)))

  ; The uncoupled branch inductances
  Lax = (quotient (imag (zpm "sp" 1 1)) w)
  Lbx = (quotient (imag (zpm "sp" 2 2)) w)
  ; M = Lc
  ; M = k*Lx
  ; k = M / Lx
  Kac = (quotient Lc Lax)
  Kbc = (quotient Lc Lbx)
  ; k = M / sqrt(Lax * Lbx)
  K = (quotient Lc (sqrt Lax * Lbx))

  ; Y Network Parameters
  ; Assumed to be in the following form.
  ;
  ; P1  O----Zz----O P2
  ;       |      |
  ;       Zx     Zy
  ;       |      |
  ; Gnd O----------O Gnd

  Y11 = (ypm "sp" port1 port1)
  Y22 = (ypm "sp" port2 port2)
  Y12 = (ypm "sp" port1 port2)

  Zx = (quotient 1.0 (plus Y11 Y12))
  Zy = (quotient 1.0 (plus Y22 Y12))
  Zz = (quotient -1.0 Y12)

  Rx = (real Zx)
  Ry = (real Zy)
  Rz = (real Zz)

  Xx = (imag Zx)
  Xy = (imag Zy)
  Xz = (imag Zz)

  Lx = (quotient Xx w)
  Ly = (quotient Xy w)
  Lz = (quotient Xz w)
  delta_L_Pi = (abs (difference Lx Ly))
  delta_L_Pi_increase = (times 100.0 (quotient delta_L_Pi (min Lx Ly)))

  Qx = (quotient Xx Rx)
  Qy = (quotient Xy Ry)
  Qz = (quotient Xz Rz)

  ; Additional measurements for using the coil
  top = Rz**2 + Xz**2
  Rz_parallel = top / Rz
  Xz_parallel = top / Xz
  Lz_parallel = (quotient Xz_parallel w)

  ; To resonate out Lz_parallel
  Cres = (1.0 / ((pow w 2.0) * Lz_parallel))

  ; Plotting the results
  plotT = (or (eq plotMode 'all) (eq plotMode 'T))
  plotPi = (or (eq plotMode 'all) (eq plotMode 'Pi))

  winId = (newWindow)
  (addTitle "Coupled Coil Analysis")

  (addSubwindowTitle "Q Factors")
  (if plotT (plot Qa Qb Qc ?expr (list "Qa (T)" "Qb (T)" "Qc (T-Virtual)")))
  (if plotPi (plot Qx Qy Qz ?expr (list "Qx (Pi)" "Qy (Pi)" "Qz (Pi-Virtual)")))

  (addSubwindow)
  (addSubwindowTitle "Resistances")
  (if plotT (plot Ra Rb Rc ?expr (list "Ra (T)" "Rb (T)" "Rc (T-Virtual)")))
  (if plotPi (plot Rx Ry Rz ?expr (list "Rx (Pi)" "Ry (Pi)" "Rz (Pi-Virtual)")))

  (addSubwindow)
  (addSubwindowTitle "Inductances")
  (if plotT (plot La
                  Lax
                  Lb
                  Lbx
                  Lc
                  delta_L_T_increase
                  ?yNumber (list 1 1 1 1 1 2)
                  ?expr (list "La (T)"
                              "Lax (T)"
                              "Lb (T)"
                              "Lbx (T)"
                              "Lc (T-Virtual)"
                              "LaLb Imbalance (%)")))
  (if plotPi (plot Lx
                   Ly
                   Lz
                   delta_L_Pi_increase
                   ?yNumber (list 1 1 1 2)
                   ?expr (list "Lx (Pi)"
                               "Ly (Pi)"
                               "Lz (Pi-Virtual)"
                               "Delta L (%)")))
  (plot K ?yNumber (list 2) ?expr (list "K"))

  (if plotPi (progn (addSubwindow)
                    (addSubwindowTitle "Miscellaneous")
                    (plot Cres
                          Lz_parallel
                          Rz_parallel
                          ?expr (list "Cres"
                                      "Lz (Parallel RL)"
                                      "Rz (Parallel RL)"))))
  (if (or (floatp f0) (integerp f0))
      (progn (awvPlaceXMarker winId f0 ?subwindow 1)
             (awvPlaceXMarker winId f0 ?subwindow 2)
             (awvPlaceXMarker winId f0 ?subwindow 3)
             (if plotPi (awvPlaceXMarker winId f0 ?subwindow 4)))))
