; A two port measurement that uses both the Y and Z parameters of a coupled
; coil to get both its T and Pi representations.
; Args:
;   f0: float
;       The frequency for the plot markers
(defun qub::ocnCoupledCoil (f0)
  f = (qub::sToF)
  w = (times 2 qub::m.PI f)

  ; T Network representation using Z-Parameters.
  ; T network is assumed to be in the following form.
  ;
  ; O---Za-----Zb---O
  ;         |
  ;         Zc
  ;         |
  ; O---------------O

  Za = (zpm "sp" 1 1) - (zpm "sp" 1 2)
  Zb = (zpm "sp" 2 2) - (zpm "sp" 1 2)
  Zc = (zpm "sp" 1 2)

  Ra = (real Za)
  Rb = (real Zb)
  Rc = (real Zc)

  Xa = (imag Za)
  Xb = (imag Zb)
  Xc = (imag Zc)

  Qa = (quotient Xa Ra)
  Qb = (quotient Xb Rb)
  Qc = (quotient Xc Rc)

  La = (quotient Xa w)
  Lb = (quotient Xb w)
  Lc = (quotient Xc w)

  Lax = (quotient (imag (zpm "sp" 1 1)) w)
  Lbx = (quotient (imag (zpm "sp" 2 2)) w)
  ; Lc = M
  ; M = k*Lx
  ; k = M / Lx
  Kac = (quotient Lc Lax)
  Kbc = (quotient Lc Lbx)

  ; Y Network Parameters
  ; Assumed to be in the following form.
  ;
  ; O----Zz----O
  ;   |      |
  ;   Zx     Zy
  ;   |      |
  ; O----------O

  Y12 = (ypm "sp" 1 2)
  Y11 = (ypm "sp" 1 1)
  Y22 = (ypm "sp" 2 2)

  Zz = (quotient -1.0 Y12)
  Zx = (quotient 1.0 (plus Y11 Y12))
  Zy = (quotient 1.0 (plus Y22 Y12))

  Rx = (real Zx)
  Ry = (real Zy)
  Rz = (real Zz)

  Xx = (imag Zx)
  Xy = (imag Zy)
  Xz = (imag Zz)

  Lx = (quotient Xx w)
  Ly = (quotient Xy w)
  Lz = (quotient Xz w)

  Qx = (quotient Xx Rx)
  Qy = (quotient Xy Ry)
  Qz = (quotient Xz Rz)

  ; Additional measurements for using the coil
  top = Rz**2 + Xz**2
  Rz_parallel = top / Rz
  Xz_parallel = top / Xz
  Lz_parallel = (quotient Xz_parallel w)

  ; To resonate out Lz_parallel
  Cres = (1.0 / ((pow w 2.0) * Lz_parallel))

  ; Plotting the results
  winId = (newWindow)
  (addTitle "Coupled Coil Analysis")

  (addSubwindowTitle "Q Factors")
  (plot Qa Qb Qc Qx Qy Qx ?expr (list "Qa (T)" "Qb (T)" "Qc (T-Virtual)" "Qx (Pi)" "Qy (Pi)" "Qz (Pi-Virtual)"))

  (addSubwindow)
  (addSubwindowTitle "Resistances")
  (plot Ra Rb Rc Rx Ry Rz ?expr (list "Ra (T)" "Rb (T)" "Rc (T-Virtual)" "Rx (Pi)" "Ry (Pi)" "Rz (Pi-Virtual)"))

  (addSubwindow)
  (addSubwindowTitle "Inductances")
  (plot La Lax Lb Lbx Lc Lx Ly Lz ?yNumber (list 1 1 1 1 1 1 1 1) ?expr (list "La (T)" "Lax (T)" "Lb (T)" "Lbx (T)" "Lc (T-Virtual)" "Lx (Pi)" "Ly (Pi)" "Lz (Pi-Virtual)"))
  (plot Kac Kbc  ?yNumber (list 2 2) ?expr (list "Kac" "Kbc"))

  (addSubwindow)
  (addSubwindowTitle "Miscellaneous")
  (plot Cres Lz_parallel Rz_parallel ?expr (list "Cres" "Lz (Parallel RL)" "Rz (Parallel RL)"))

  (awvPlaceXMarker winId f0 ?subwindow 1)
  (awvPlaceXMarker winId f0 ?subwindow 2)
  (awvPlaceXMarker winId f0 ?subwindow 3)
  (awvPlaceXMarker winId f0 ?subwindow 4))
