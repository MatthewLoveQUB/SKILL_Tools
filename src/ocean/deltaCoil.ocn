simulator( 'spectre )
design(	 "/data/p_outpa_extra01/mlove/simulation/deltaWithPadsAndGroundCutTb/spectre/schematic/netlist/netlist")
resultsDir( "/data/p_outpa_extra01/mlove/simulation/deltaWithPadsAndGroundCutTb/spectre/schematic" )
modelFile(
    '("/cadappl/iclibs/tsmc/CRN28HPC/T-N28-CR-SP-020/1_0_2P1//toplevel.scs" "top_tt")
    '("/cadappl/iclibs/tsmc/CRN28HPC/T-N28-CR-SP-020/1_0_2P1//toplevel.scs" "pre_simu")
)
definitionFile(
    "/user/p_outpa/.caddata/tcbn28hpcbwp35p140/Back_End/spice/tcbn28hpcbwp35p140_100a/tcbn28hpcbwp35p140_100a.spi"
    "/user/p_outpa/.caddata/tcbn28hpcbwp35p140lvt/Back_End/spice/tcbn28hpcbwp35p140lvt_100a/tcbn28hpcbwp35p140lvt_100a.spi"
    "/user/p_outpa/.caddata/tphn28hpcgv18e/Back_End/spice/tphn28hpcgv18e_120a/tphn28hpcgv18e.spi"
)

(analysis 'sp ?ports list("/PORT0" "/PORT1" "/PORT2")  ?start "1G"  ?stop "15G")
(envOption 'analysisOrder  list("sp"))
(temp 27)
(run)

f = (qub::sToF)
w = (times 2 qub::m.PI f)

y12 = (times -1.0 (ypm "sp" 1 2))
y13 = (times -1.0 (ypm "sp" 1 3))
y23 = (times -1.0 (ypm "sp" 2 3))

z12 = (quotient 1 y12)
z13 = (quotient 1 y13)
z23 = (quotient 1 y23)

r12 = (real z12)
r13 = (real z13)
r23 = (real z23)

x12 = (imag z12)
x13 = (imag z13)
x23 = (imag z23)

q12 = (quotient x12 r12)
q13 = (quotient x13 r13)
q23 = (quotient x23 r23)

l12 = (quotient x12 w)
l13 = (quotient x13 w)
l23 = (quotient x23 w)

winId = (newWindow)
(plot q12 q13 q23 ?expr (list "Q12" "Q13" "Q23"))

(addSubwindow)
(plot r12 r13 r23 ?expr (list "R12" "R13" "R23"))

(addSubwindow)
(plot l12 l13 l23 ?expr (list "L12" "L13" "L23"))

(addSubwindow)
Cres = (quotient 1.0 (times w w l23))
(plot Cres ?expr (list "C Resonator"))

Xs = x23
Rs = r23
top = (plus (times Xs Xs) (times Rs Rs))
Rp = (quotient top Rs)
Xp = (quotient top Xs)
(plot Rp ?expr (list "R Shunt"))

Rideal = 100.0
Rnew = (quotient 1.0
                 (difference (quotient 1.0 Rideal)
                       (quotient 1.0 Rp)))
(plot Rnew ?expr (list "Rnew"))

(awvPlaceXMarker winId 5G ?subwindow 1)
(awvPlaceXMarker winId 5G ?subwindow 2)
(awvPlaceXMarker winId 5G ?subwindow 3)
(awvPlaceXMarker winId 5G ?subwindow 4)
