(defun qub:::getSpectreSimFiles ()
  (letseq ((spectreObj (asiGetTool 'spectre))
           (rawFiles (asiGetEnvOptionVal spectreObj 'allDefinitionFiles)))
    (mapcar cadr rawFiles)))

(defun qub:::getModelFiles ()
  (letseq ((spectreObj (asiGetTool 'spectre))
           (rawFiles (asiGetEnvOptionVal spectreObj 'modelFiles)))
    (setof x rawFiles (or (equal "top_tt" (cadr x))
                          (equal "pre_simu" (cadr x))))))

(defmacro qub::simPreamble (lib schem @key (view "schematic"))
  `(progn
    (simulator 'spectre)
    ; Turn off Spectre logging to speed up simulation time
    (envSetVal "asimenv.misc" "includeSimLogInOCEAN" 'boolean nil)
    (design ,lib ,schem ,view)
    ; Look for the preloaded model and definition files
    (apply 'modelFile (qub:::getModelFiles))
    (apply 'definitionFile (qub:::getSpectreSimFiles))
    (createNetlist ?recreateAll t)
    (resultsDir (sprintf nil "/user/p_outpa/mlove/%s/%s/" ,lib ,schem))))

; Create a new window in the smith chart mode
; Args:
;   smithTypeStr: string
;                 Either "impedance", "admittance", or "polar"
(defun qub::createSmith (@optional (smithTypeStr "impedance"))
  (newWindow)
  (displayMode "smith")
  (smithType smithTypeStr))

; Gets the frequency data from the results of an S-Parameter simulation
(defun qub::sToF ()
  (xval (getData "/s11" ?result "sp")))
