; Evaluate a component using a one-port s-parameter simulation
; mode can be 'C, 'L, or 'all
(defun qub::ocnPassiveOnePort (@key (port 1)
                                    (mode 'all)
                                    (markerFreq nil)
                                    (plotTitle "Passive Plot"))
  (letseq ((f (qub::sToF))
           (w (times 2.0 qub::m.PI f))
           (Z (zpm "sp" port port))
           (Rs (real Z))
           (X (imag Z))
           (Qs (quotient (abs X) Rs))
           (Ls (qub::XToL X w))
           (Cs (qub::XToC X w))
           (Y (ypm "sp"  port port))
           (Rp (quotient 1.0 (real Y)))
           (Xp (quotient -1.0 (imag Y)))
           (Lp (qub::XToL Xp w))
           (Cp (qub::XToC Xp w))
           (winId (newWindow))
           (numSubwindows (if (equal mode 'all) 4 2)))
    (addTitle plotTitle)
    (if (or (equal mode 'all) (equal mode 'L))
        (progn (addSubwindowTitle "Series RL")
               (plot Rs X Qs ?expr (list "R" "X" "Q"))
               (plot Ls ?expr (list "L") ?yNumber 2)
               (addSubwindow)
               (addSubwindowTitle "Parallel RL")
               (plot Rp Xp ?expr (list "R" "X"))
               (plot Lp ?expr (list "L") ?yNumber 2)))
    (if (equal mode 'all)
        (addSubwindow))
    (if (not (equal mode 'L))
        (progn (addSubwindowTitle "Series RC")
               (plot Rs X Qs ?expr (list "R" "X" "Q"))
               (plot Cs ?expr (list "C") ?yNumber 2)
               (plot (abs Z) ?expr (list "|Z|"))
               (addSubwindow)
               (addSubwindowTitle "Parallel RC")
               (plot Rp Xp ?expr (list "R" "X"))
               (plot Cp ?expr (list "C") ?yNumber 2)))
    (foreach n (qub::range ?start 1 ?stop numSubwindows+1 ?step 1)
      (awvPlaceXMarker winId markerFreq ?subwindow n))
    t))
