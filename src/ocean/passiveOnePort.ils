; Evaluate a passive component using a one-port S-parameter simulation
; Args:
;   port: int
;         The index of the S-parameter port to analyse
;   plotMode: symbol
;             Can be 'sL, 'pL, 'sC, 'pC for
;             series inductance, parallel inductance etc
;   markerFreq: float
;               Places a vertical marker in all plots at the desired frequency
;   singleFreq: float
;               Restrict the plot to values for a single frequency
;               If it is not nil, markerFreq is ignored
;   plotTitle: string
;              The title of the ViVA plot
(defun qub::ocnPassiveOnePort (@key (port 1)
                                    (markerFreq nil)
                                    (plotTitle "Passive Plot")
                                    (singleFreq nil)
                                    (plotMode (list 'sL 'pL 'sC 'pC)))
  (letseq ((f (qub::sToF))
           (w (times 2.0 qub::m.PI f))
           (Z (zpm "sp" port port))
           (Rs (real Z))
           (X (imag Z))
           (Qs (quotient (abs X) Rs))
           (Ls (qub::XToL X w))
           (Cs (qub::XToC X w))
           (Y (ypm "sp"  port port))
           (Rp (quotient 1.0 (real Y)))
           (Xp (quotient -1.0 (imag Y)))
           (Lp (qub::XToL Xp w))
           (Cp (qub::XToC Xp w))
           (winId (newWindow))
           (isSingleFreq (not (null singleFreq))))
    (defun changeVarSingleFreq (_var)
      (if isSingleFreq (value _var singleFreq) _var))
    (let ((Z (changeVarSingleFreq Z))
          (Rs (changeVarSingleFreq Rs))
          (X (changeVarSingleFreq X))
          (Qs (changeVarSingleFreq Qs))
          (Ls (changeVarSingleFreq Ls))
          (Cs (changeVarSingleFreq Cs))
          (Rp (changeVarSingleFreq Rp))
          (Xp (changeVarSingleFreq Xp))
          (Lp (changeVarSingleFreq Lp))
          (Cp (changeVarSingleFreq Cp)))
      (define (plotSeriesInductance)
        (addSubwindowTitle "Series RL")
        (plot Rs X Qs ?expr (list "R" "X" "Q"))
        (plot Ls ?expr (list "L") ?yNumber 2))
      (define (plotParallelInductance)
        (addSubwindowTitle "Parallel RL")
        (plot Rp Xp ?expr (list "R" "X"))
        (plot Lp ?expr (list "L") ?yNumber 2))
      (define (plotSeriesCapacitance)
        (addSubwindowTitle "Series RC")
        (plot Rs X Qs ?expr (list "R" "X" "Q"))
        (plot Cs ?expr (list "C") ?yNumber 2)
        (plot (abs Z) ?expr (list "|Z|")))
      (define (plotParallelCapacitance)
        (addSubwindowTitle "Parallel RC")
        (plot Rp Xp ?expr (list "R" "X"))
        (plot Cp ?expr (list "C") ?yNumber 2))
      (let ((plotFns (makeTable "plotFunTable" 0)))
        plotFns['sL] = plotSeriesInductance
        plotFns['pL] = plotParallelInductance
        plotFns['sC] = plotSeriesCapacitance
        plotFns['pC] = plotParallelCapacitance
        (addTitle plotTitle)
      (foreach symIdx (qub::range ?start 0 ?stop (length plotMode))
        ((plotFns[(nth symIdx plotMode)]))
        (if (and (not (null markerFreq)) (null singleFreq))
            (awvPlaceXMarker winId markerFreq ?subwindow symIdx+1))
        (if (equal symIdx (difference (length plotMode) 1))
            t
            (addSubwindow)))
        t))))
