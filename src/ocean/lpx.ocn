(qub::simPreamble "mlove_lib" "load_pull2")

analysis('pss ?engine "Harmonic Balance"  ?flexbalance "yes"  ?oversamplefactor ""
		?fund "5G"  ?harms "30"  ?errpreset "conservative"  ?loadinst "/PORT1"
		?loadinst_info "(quote (nil instType port))"
		?sweepvar_info "(quote (nil theta (nil step \"20\" stepTypeLog \"Points Per Decade\" stepTypeLin \"Step Size\" incrType \"Linear\" stop \"160\" start \"-180\" rangeType \"Start-Stop\") mag (nil step \"0.11\" stepTypeLog \"Points Per Decade\" stepTypeLin \"Step Size\" incrType \"Linear\" stop \"0.991\" start \"0.001\" rangeType \"Start-Stop\")))"
		?rho "mag"  ?phi "theta"  ?z0 "50"
		?step ""  ?write ""  ?writefinal ""  ?swapfile ""
		?checkpss ""  ?backtracking ""  )

desVar(	  "mag" 0	)
desVar(	  "theta" 0	)

run()
(newWindow)
(displayMode "smith")
(smithType "impedance")

myVar1 = (awvRfLoadPull (pvi('pss "/out" 0 "/PORT1/PLUS" 0 '(1)) / (- pvi('pss "/in" 0 "/PORT0/PLUS" 0 '1))) ?maxValue nil ?minValue 0 ?numCont 9 ?closeCont t)
plot( myVar1 ?expr '( "myVar1" ) )

myVar2 = (awvRfLoadPull ((100.0 * harmonic((spectralPower(i("/PORT1/PLUS" ?result "pss_fd") v("/out" ?result "pss_fd")) + spectralPower(i("/PORT0/PLUS" ?result "pss_fd") v("/in" ?result "pss_fd"))) '(1))) / (- harmonic(spectralPower(i("/L1/PLUS" ?result "pss_fd") v("/vdd!" ?result "pss_fd")) '(0)))) ?maxValue nil ?minValue 0 ?numCont 9 ?closeCont t)

plot( myVar2 ?expr '( "myVar2" ) )

outcurr = i("/PORT1/PLUS" ?result "pss_fd")
outvolt = v("/out" ?result "pss_fd")
constantPowerContours = (cPwrContour outcurr
                                     outvolt
                                     '1
                                     ?minPower 0
                                     ?refImp 50.0
                                     ?numCont 9
                                     ?closeCont t
                                     ?modifier "dBm")

(plot constantPowerContours ?expr '( "Constant Power Contours" ) )
