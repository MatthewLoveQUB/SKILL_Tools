; testType must be "pss" or "hb"
(defun qub::ocnLoadPull (@key (minPout 0)
                              (minPae 0)
                              (outName nil)
                              (inName nil)
                              (vddName nil)
                              (testType nil)
                              (nContours 6))
	(cond ((not testType)
         (error "testType not \"hb\" or \"pss\""))
        ((not outName)
         (error "Provide a name for the output port \"outName\"."))
        ((not inName)
         (error "Provide a name for the in port \"inName\"."))
        ((not vddName)
         (error "Provide a name for the supply component \"vddName\".")))
  (qub::createSmith)

  testType = (strcat testType "_fd")

	outCurrent = (i (sprintf nil "/%s/PLUS" outName) ?result testType)
	outVoltage = (v "/out" ?result testType)
	outPower = (spectralPower outCurrent outVoltage)

	inCurrent = (i (sprintf nil "/%s/PLUS" inName) ?result testType)
	inVoltage = (v "/in" ?result testType)
	inPower = (spectralPower inCurrent inVoltage)

	dcCurrent = (i (sprintf nil "/%s/PLUS" vddName) ?result testType)
	dcVoltage = (v "/supply" ?result testType)
	dcPower = (minus (harmonic (spectralPower dcCurrent dcVoltage) 0))

	rfPower = (harmonic outPower 1) + (harmonic inPower 1)

  PAE = (awvRfLoadPull (100.0 * (rfPower/dcPower))
					   ?maxValue 100.0
					   ?minValue minPae
					   ?numCont nContours
					   ?closeCont nil)

	(plot PAE ?expr '("PAE"))

	powerContours = (cPwrContour outCurrent
							   outVoltage
							   '1
							   ?refImp 50.0
							   ?numCont nContours
							   ?minPower minPout
							   ?closeCont nil
							   ?modifier "dBm")

	(plot powerContours ?expr '("Po")))
