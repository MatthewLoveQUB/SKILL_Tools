; Process a one-port S-Parameter simulation to measure the capacitance of a circuit

(defun qub::ocnCapOnePort (f0)
f = (qub::sToF)
  w = (times 2 qub::m.PI f)

  z1 = (zpm "sp" 1 1)

  ; Reactance
  XC = (imag z1)
  XC_abs = (abs XC)

  ; Capacitance
  C = 1.0/(XC_abs*w)

  ; Resistance
  R = (real z1)

  ; Q Factor
  Q = XC_abs/R

  ; Parallel resistance, reactance and capacitance
  Rp = (R**2 + XC_abs**2)/R
  Xp = (R**2 + XC_abs**2)/XC_abs
  Cp = 1/(Xp*w)

  winId = (newWindow)
  (plot Q R XC Rp Xp ?expr (list "Q" "R" "XC" "R (Parallel)" "X (Parallel)"))

  (addSubwindow)
  (plot C Cp ?expr (list "C" "C (Parallel)"))

  (awvPlaceXMarker winId f0 ?subwindow 1)
  (awvPlaceXMarker winId f0 ?subwindow 2))
