; outName: instance name of the output port
; inName: instance name of the input port
; vddName: instance name of the DC voltage source
; testType: varies if pss or hb
; hb_fd: harmonic balance
; pss_fd: pss (not verified)
(defun qub::ocnAmpHb (@key (outName nil)
                           (inName nil)
                           (vddName nil)
                           (testType nil)
                           (supplyNet nil)
                           (outNet nil)
                           (inNet nil))

  ; Set up the terminals and ports
  ; Output port instance
  outPortInst = outName
  ; Output node
  outNode = (sprintf nil "/%s/PLUS" outPortInst)
  ; Input port instance
  inPortInst = inName
  ; Input node
  inNode = (sprintf nil "/%s/PLUS" inPortInst)
  ; Voltage supply instance
  suppleInst = vddName
  ; Voltage supply node
  supplyNode = (sprintf nil "/%s/PLUS" suppleInst)

  ; The output harmonic we want to extract
  harmOut = 1
  ; The DC harmonic
  harmDc = 0
  ; The ground terminal
  gndTerm = 0
  ; Simulation type
  simType = (if (equal testType "hb") 'hb 'pss)
  (printf "Assuming sim type: '%s'\n" simType)
  ; Simulation results type
  simResultType = (if (equal testType "hb") "hb_fd" "pss_fd")
  ; Output power watts
  pwrOutWatts = (pvi simType outNet gndTerm outNode gndTerm)
  ; Output power dBm
  pwrOutDbm = (dbm pwrOutWatts)
  ; Input power watts
  pwrInWatts = (- (pvi simType inNet gndTerm inNode gndTerm))
  ; Gain
  Gain = (db10 (pwrOutWatts / pwrInWatts))

  supplyVoltage = (v supplyNet ?result simResultType)
  supplyCurrent = (i supplyNode ?result simResultType)
  spectralPwrDc = (spectralPower supplyCurrent supplyVoltage)

  outCurrent = (i outNode ?result simResultType)
  outVoltage = (v outNet ?result simResultType)
  spectralPwrOut = (spectralPower outCurrent outVoltage)

  inCurrent = (i inNode ?result simResultType)
  inVoltage = (v inNet ?result simResultType)
  spectralPwrIn = (spectralPower inCurrent inVoltage)

    ; Denominator and numerator for PAE
  paeDenom = (100.0 * (harmonic (spectralPwrOut + spectralPwrIn) harmOut))
  paeNum = (- (harmonic spectralPwrDc harmDc))
  PAE = paeDenom / paeNum

  ; Numerator for drain efficiency
  ; It shares the same denominator
  deDenom = (100.0 * (harmonic spectralPwrOut harmOut))

  drainEff = deDenom / paeNum

  winId = (newWindow)
  (addTitle (sprintf nil "Amp HB (PAE: %.2f%%, DE: %.2f%%)" PAE drainEff))
  (plot pwrOutDbm ?expr (list "Pout"))
  (addSubwindow)
  (plot Gain ?expr (list "Gain")))
