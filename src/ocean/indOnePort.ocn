; Process a one-port S-Parameter simulation to measure the inductance of a circuit

(defun qub::ocnIndOnePort (f0)
  f = (qub::sToF)
  w = (times 2 qub::m.PI f)

  ; Complex impedance
  Z = (zpm "sp" 1 1)

  ; Resistance and reactance
  R = (real Z)
  XL = (imag Z)

  ; Inductance
  L = XL/w

  ; Q Factor
  Q = XL/R

  ; Parallel resistance, reactance and inductance
  Rp = (XL**2 + R**2)/R
  Xp = (XL**2 + R**2)/XL
  Lp = Xp/w

  ; Plot the data
  winId = (newWindow)
  (plot Q R XL Rp Xp ?expr (list "Q" "R" "XL" "Rp" "Xp"))

  (addSubwindow)
  (plot L Lp ?expr (list "L" "Lp"))

  (awvPlaceXMarker winId f0 ?subwindow 1)
  (awvPlaceXMarker winId f0 ?subwindow 2))
