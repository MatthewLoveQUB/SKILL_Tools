(defun nmosLoadPull (schematicName)
  (qub::simPreamble "mlove_lib" schematicName)
  (let ((lpSweep '(nil theta (nil step 20
                                  stepTypeLog "Points Per Decade"
                                  stepTypeLin "Step Size"
                                  incrType "Linear"
                                  stop 160
                                  start -180
                                  rangeType "Start-Stop")
                       mag (nil step 0.11
                                stepTypeLog "Points Per Decade"
                                stepTypeLin "Step Size"
                                incrType "Linear"
                                stop 0.991
                                start 0.001
                                rangeType "Start-Stop")))
      (PAE nil)
      (constantPowerContours nil))
    (analysis 'pss
              ?engine "Harmonic Balance"
              ?flexbalance "yes"
              ?fund 5G
              ?oversamplefactor ""
              ?harms 30
              ?errpreset "conservative"
              ?loadinst "/PORT1"
              ?loadinst_info "(quote (nil instType port))"
              ?rho "mag"
              ?phi "theta"
              ?z0 50
              ?step ""
              ?write ""
              ?writefinal ""
              ?swapfile ""
              ?checkpss ""
              ?backtracking ""
              ?sweepvar_info (sprintf nil "%A" lpSweep))
    (desVar	"mag" 0)
    (desVar "theta" 0)
    (save 'all)

    (run)

    (openResults (sprintf nil "%s/psf" (resultsDir)))
    (newWindow)
    (displayMode "smith")
    (smithType "polar")
    (selectResult 'pss_fi)

    ; Plotting the power contours
    (letseq ((outCurrent (i "/PORT1/PLUS"))
             (outVoltage (v "/out")))
      (setq constantPowerContours (cPwrContour outCurrent
                                               outVoltage
                                               '1
                                               ?minPower 0
                                               ?refImp 50.0
                                               ?numCont 9
                                               ?closeCont t
                                               ?modifier "dBm")))

    ; Plotting PAE contours
    (letseq ((port1Current (i "/PORT1/PLUS"))
             (port1Voltage (v "/out" ))
             (outPwr (spectralPower port1Current port1Voltage))
             (port0Current (i "/PORT0/PLUS"))
             (port0Voltage (v "/in"))
             (inPwr (spectralPower port0Current port0Voltage))
             (dcCurrent (i "/L1/PLUS"))
             (dcVoltage (v "/vdd!"))
             (pwrDC (minus (harmonic (spectralPower dcCurrent dcVoltage) 0)))
             (pwr5GHz (harmonic (outPwr + inPwr) 1))
             (paeVal (quotient (times 100.0 pwr5GHz) pwrDC)))
      (setq PAE (awvRfLoadPull paeVal
                               ?maxValue nil
                               ?minValue 35
                               ?numCont 9
                               ?closeCont t)))

  (plot constantPowerContours ?expr (list "Constant Power Contours"))
  (plot PAE ?expr (list "PAE"))))

(nmosLoadPull "load_pull2")
