;;;; This is a reference file for running load pull simulations
;;;; It should be copied and modified to work with your current design

; Design variables
inputPower = 10
fund = 5G
vgs = 700m
fetWidth = 8u
fetLength = 180n
fetNFingers = 14
fetMult = 1

(when t
  (qub::simPreamble "mlove_driver" "loadPull_1p8")

  lpSweep = '(quote (nil theta (nil step "20"
                                    stepTypeLog "Points Per Decade"
                                    stepTypeLin "Step Size"
                                    incrType "Linear"
                                    stop "160"
                                    start "-180"
                                    rangeType "Start-Stop")
                         mag (nil step "0.11"
                                  stepTypeLog "Points Per Decade"
                                  stepTypeLin "Step Size"
                                  incrType "Linear"
                                  stop "0.991"
                                  start "0.001"
                                  rangeType "Start-Stop")))

  (analysis 'pss
            ?engine "Harmonic Balance"
            ?flexbalance "yes"
            ?oversamplefactor ""
            ?fund (sprintf nil "%n" fund)
            ?harms "30"
            ?errpreset "conservative"
            ?loadinst "/PORT1"
            ?loadinst_info "(quote (nil instType port))"
            ?sweepvar_info (sprintf nil "%A" lpSweep)
            ?rho "mag"
            ?phi "theta"
            ?z0 "50"
            ?step ""
            ?write ""
            ?writefinal ""
            ?swapfile ""
            ?checkpss ""
            ?save "all"
            ?backtracking "")

  (desVar	"mag" 0)
  (desVar	"theta" 0)
  (envOption 'analysisOrder  list("pss"))

  (saveOption 'currents "all")
  (saveOption 'pwr "all")
  (saveOption 'save "all")
  (temp 27)

  (desVar "VGS" vgs)
  (desVar "fetWidth" fetWidth)
  (desVar "fetLength" fetLength)
  (desVar "fetMult" fetMult)
  (desVar "fetNFingers" fetNFingers)
  (desVar "inputPower" inputPower)
  (desVar "fund" fund)

  (run))

(qub::createSmith)

title = (sprintf nil
                 "VG%0.2f W%s L%s F%d M%d"
                 vgs
                 (aelSuffixNotation fetWidth)
                 (aelSuffixNotation fetLength)
                 fetNFingers
                 fetMult)
(addTitle title)

outCurrent = (i "/PORT1/PLUS" ?result "pss_fd")
outVoltage = (v "/out" ?result "pss_fd")
outPower = (spectralPower outCurrent outVoltage)

inCurrent = (i "/PORT0/PLUS" ?result "pss_fd")
inVoltage = (v "/in" ?result "pss_fd")
inPower = (spectralPower inCurrent inVoltage)

dcCurrent = (i "/V1/PLUS" ?result "pss_fd")
dcVoltage = (v "/net5" ?result "pss_fd")
dcPower = (minus (harmonic (spectralPower dcCurrent dcVoltage) 0))

rfPower = (harmonic (plus outPower inPower) 1)

PAE = (awvRfLoadPull (times 100.0 (quotient rfPower dcPower))
                     ;?maxValue 100
                     ;?minValue 10
                     ?numCont 9
                     ?closeCont t)

(plot PAE ?expr '("PAE"))

powerContours = (cPwrContour outCurrent
                             outVoltage
                             '1
                             ;?maxPower
                             ;?minPower
                             ?refImp 50.0
                             ?numCont 9
                             ?closeCont t
                             ?modifier "dBm")

(plot powerContours ?expr '("Po"))
