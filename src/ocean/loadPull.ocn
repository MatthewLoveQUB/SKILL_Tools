; Design variables
inputPower = 7
fund = 5G
vgs = 0.450
fetWidth = 3u
fetLength = 30n
fetNFingers = 32
fetMult = 10
VDD = 0.9

; Setting up test
(qub::simPreamble "mlove_test" "loadPull")

lpSweep = '(quote (nil theta (nil step "20"
                                  stepTypeLog "Points Per Decade"
                                  stepTypeLin "Step Size"
                                  incrType "Linear"
                                  stop "360"
                                  start "0"
                                  rangeType "Start-Stop")
                       mag (nil step "0.11"
                                stepTypeLog "Points Per Decade"
                                stepTypeLin "Step Size"
                                incrType "Linear"
                                stop "0.991"
                                start "0.001"
                                rangeType "Start-Stop")))

(analysis 'pss
          ?engine "Harmonic Balance"
          ?flexbalance "yes"
          ?oversamplefactor ""
          ?fund (sprintf nil "%n" fund)
          ?harms "30"
          ?errpreset "conservative"
          ?loadinst "/PORT1"
          ?loadinst_info "(quote (nil instType port))"
          ?sweepvar_info (sprintf nil "%A" lpSweep)
          ?rho "mag"
          ?phi "theta"
          ?z0 "50"
          ?step ""
          ?write ""
          ?writefinal ""
          ?swapfile ""
          ?checkpss ""
          ?save "all"
          ?backtracking "")

(desVar	"mag" 0)
(desVar	"theta" 0)
(envOption 'analysisOrder  list("pss"))

(saveOption 'currents "all")
(saveOption 'pwr "all")
(saveOption 'save "all")
(temp 27)

(foreach loopVar (qub::range ?start 0 ?stop 1 ?step 1)
  VDD = 0.9 + (loopVar * 0.9)

  (desVar "VGS" vgs)
  (desVar "fetWidth" fetWidth)
  (desVar "fetLength" fetLength)
  (desVar "fetMult" fetMult)
  (desVar "fetNFingers" fetNFingers)
  (desVar "inputPower" inputPower)
  (desVar "fund" fund)
  (desVar "VDD" VDD)

  (run)

  (qub::createSmith)

  title = (sprintf nil
                   "VDD%0.1f Pin%d VG%0.2f W%s L%s F%d M%d"
                   VDD
                   inputPower
                   vgs
                   (aelSuffixNotation fetWidth)
                   (aelSuffixNotation fetLength)
                   fetNFingers
                   fetMult)
  (addTitle title)

  outCurrent = (i "/PORT1/PLUS" ?result "pss_fd")
  outVoltage = (v "/out" ?result "pss_fd")
  outPower = (spectralPower outCurrent outVoltage)

  inCurrent = (i "/PORT0/PLUS" ?result "pss_fd")
  inVoltage = (v "/in" ?result "pss_fd")
  inPower = (spectralPower inCurrent inVoltage)

  dcCurrent = (i "/V1/PLUS" ?result "pss_fd")
  dcVoltage = (v "/supply" ?result "pss_fd")
  dcPower = (minus (harmonic (spectralPower dcCurrent dcVoltage) 0))

  rfPower = (harmonic (plus outPower inPower) 1)

  PAE = (awvRfLoadPull (times 100.0 (quotient rfPower dcPower))
                       ?maxValue 100
                       ?minValue 40
                       ?numCont 9
                       ?closeCont nil)

  (plot PAE ?expr '("PAE"))

  powerContours = (cPwrContour outCurrent
                               outVoltage
                               '1
                               ?refImp 50.0
                               ?numCont 9
                               ?minPower 10.0
                               ?closeCont nil
                               ?modifier "dBm")

  (plot powerContours ?expr '("Po")))
