; Plot drain efficiency (DE) and power-added efficiency (PAE) for an amplifier
; where the two inputs are outphased.
; Assuming the simulation was done by sweeping the phase difference
; between the power of the two input ports, the DE and PAE will be plotted
; against the phase angle in radians and the output power back-off
; Args:
;   outName: string
;            Name of the output node
;
;   inName: string
;           Name of the input node
;   vddName: string
;            Instance name of the DC voltage source
;   testType: string
;             Either "hb" or "pss" for harmonic balance or periodic steady
;             state simulations respectively.
(defun qub::ocnOutphasingSweep (@key (outNode nil)
                                     (inNode1 nil)
                                     (inNode2 nil)
                                     (vddNode nil)
                                     (testType nil)
                                     (supplyNet nil)
                                     (outNet nil)
                                     (inNet1 nil)
                                     (inNet2 nil))
  (letseq ((fundamentalHarmonicIndex 1)
           (dcHarmonicIndex 0)
           (gndNet 0)
           ; Determine simulation type
           ; Should only really be HB or PSS
           (simType (if (equal testType "hb")
                        'hb
                        'pss))
           (simResultType (if (equal testType "hb")
                              "hb_fd"
                              "pss_fd"))
           (pvix
             (lambda (net node)
               (pvi simType net gndNet node gndNet fundamentalHarmonicIndex)))
           (outputPowerWatts (pvix outNet outNode))
           (outputPowerDbm (dbm outputPowerWatts))
           (inputPowerWatts1 (minus (pvix inNet1 inNode1)))
           (inputPowerWatts2 (minus (pvix inNet2 inNode2)))
           (vx (lambda (net) (v net ?result simResultType)))
           (ix (lambda (node) (i node ?result simResultType)))
           (supplyVoltage (vx supplyNet))
           (supplyCurrent (ix vddNode))
           (spectralDcPower (spectralPower supplyCurrent supplyVoltage))
           (outCurrent (ix outNode))
           (outVoltage (vx outNet))
           (spectralOutputPower (spectralPower outCurrent outVoltage))
           (inCurrent1 (ix inNode1))
           (inVoltage1 (vx inNet1))
           (spectralInputPower1 (spectralPower inCurrent1 inVoltage1))
           (inCurrent2 (ix inNode2))
           (inVoltage2 (vx inNet2))
           (spectralInputPower2 (spectralPower inCurrent2 inVoltage2))
           (paeNumerator (times 100.0
                                (harmonic
                                  (plus spectralOutputPower
                                        spectralInputPower1
                                        spectralInputPower2)
                                fundamentalHarmonicIndex)))
           (paeDenominator (minus (harmonic spectralDcPower dcHarmonicIndex)))
           (pae (quotient paeNumerator paeDenominator))
           (drainEfficiencyNumerator
             (times 100.0 (harmonic spectralOutputPower
                                    fundamentalHarmonicIndex)))
           (drainEfficiency (quotient drainEfficiencyNumerator
                                      paeDenominator))
           (backoff_simulated (difference outputPowerDbm
                                          (ymax outputPowerDbm))))
    (printf "Assuming sim type: '%s'\n" simType)
    (plot outputPowerDbm
          drainEfficiency
          ?expr (list "Output Power (dBm)" "Drain Efficiency"))
    (awvSetXAxisLabel (currentWindow) "Phase Angle (rad)")
    (addSubwindow)
    (ocnYvsYplot ?wavex backoff_simulated
                 ?wavey drainEfficiency
                 ?titleList (list "Drain Efficiency (%)")
                 ?colorList (list "y2"))
    (ocnYvsYplot ?wavex backoff_simulated
                 ?wavey pae
                 ?titleList (list "PAE (%)")
                 ?colorList (list "y2"))
    (awvSetXAxisLabel (currentWindow) "Backoff")))
