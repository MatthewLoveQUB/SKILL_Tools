simulator( 'spectre )
design(	 "/data/p_outpa_extra01/mlove/simulation/load_pull2/spectre/schematic/netlist/netlist")
resultsDir( "/data/p_outpa_extra01/mlove/simulation/load_pull2/spectre/schematic" )
modelFile(
    '("/cadappl/iclibs/tsmc/CRN28HPC/T-N28-CR-SP-020/1_0_2P1//toplevel.scs" "top_tt")
    '("/cadappl/iclibs/tsmc/CRN28HPC/T-N28-CR-SP-020/1_0_2P1//toplevel.scs" "pre_simu")
)

definitionFile(
    "/user/p_outpa/.caddata/tcbn28hpcbwp35p140/Back_End/spice/tcbn28hpcbwp35p140_100a/tcbn28hpcbwp35p140_100a.spi"
    "/user/p_outpa/.caddata/tcbn28hpcbwp35p140lvt/Back_End/spice/tcbn28hpcbwp35p140lvt_100a/tcbn28hpcbwp35p140lvt_100a.spi"
    "/user/p_outpa/.caddata/tphn28hpcgv18e/Back_End/spice/tphn28hpcgv18e_120a/tphn28hpcgv18e.spi"
)

analysis('pss ?engine "Harmonic Balance"  ?flexbalance "yes"  ?oversamplefactor ""
		?fund "5G"  ?harms "30"  ?errpreset "conservative"  ?loadinst "/PORT1"
		?loadinst_info "(quote (nil instType port))"
		?sweepvar_info "(quote (nil theta (nil step \"20\" stepTypeLog \"Points Per Decade\" stepTypeLin \"Step Size\" incrType \"Linear\" stop \"160\" start \"-180\" rangeType \"Start-Stop\") mag (nil step \"0.11\" stepTypeLog \"Points Per Decade\" stepTypeLin \"Step Size\" incrType \"Linear\" stop \"0.991\" start \"0.001\" rangeType \"Start-Stop\")))"
		?rho "mag"  ?phi "theta"  ?z0 "50"
		?step ""  ?write ""  ?writefinal ""  ?swapfile ""
		?checkpss ""  ?backtracking ""  )

desVar(	  "mag" 0	)
desVar(	  "theta" 0	)

envOption(
	'analysisOrder  list("pss")
)

option(	'temp  "27.0"
)

temp( 27.0 )

run()

\(p\(\/PORT1\/PLUS\ \/out\)\ h\=1\)\/\(p\(\/PORT0\/PLUS\ \/in\)\ h\=1\)\ pss\ mag\(P\/P\) = (awvRfLoadPull (pvi('pss "/out" 0 "/PORT1/PLUS" 0 '(1)) / (- pvi('pss "/in" 0 "/PORT0/PLUS" 0 '1))) ?maxValue nil ?minValue 0 ?numCont 9 ?closeCont t)
plot( \(p\(\/PORT1\/PLUS\ \/out\)\ h\=1\)\/\(p\(\/PORT0\/PLUS\ \/in\)\ h\=1\)\ pss\ mag\(P\/P\) ?expr '( "(p(/PORT1/PLUS /out) h=1)/(p(/PORT0/PLUS /in) h=1) pss mag(P/P)" ) )

\1\0\0\.\*\(p\(\/PORT1\/PLUS\ \/out\)\-p\(\/PORT0\/PLUS\ \/in\)\)\/Pdc\(1\)\ \ pss\ P\/P = (awvRfLoadPull ((100.0 * harmonic((spectralPower(i("/PORT1/PLUS" ?result "pss_fd") v("/out" ?result "pss_fd")) + spectralPower(i("/PORT0/PLUS" ?result "pss_fd") v("/in" ?result "pss_fd"))) '(1))) / (- harmonic(spectralPower(i("/L1/PLUS" ?result "pss_fd") v("/vdd!" ?result "pss_fd")) '(0)))) ?maxValue nil ?minValue 0 ?numCont 9 ?closeCont t)

plot( \1\0\0\.\*\(p\(\/PORT1\/PLUS\ \/out\)\-p\(\/PORT0\/PLUS\ \/in\)\)\/Pdc\(1\)\ \ pss\ P\/P ?expr '( "100.*(p(/PORT1/PLUS /out)-p(/PORT0/PLUS /in))/Pdc(1)  pss P/P" ) )

Constant\ Power\ Contours = cPwrContour(i("/PORT1/PLUS" ?result "pss_fd") v("/out" ?result "pss_fd") '1 ?minPower 0 ?refImp 50.0 ?numCont 9 ?closeCont t ?modifier "dBm")

plot( Constant\ Power\ Contours ?expr '( "Constant Power Contours" ) )
