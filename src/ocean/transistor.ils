; For plotting transistory things

; Return 0 if the net can't be plotted
; it's usually gnd
; s_ana = analysis type ('hb, 'pss, 'tran)
(defun qub::getNetVoltageSafe (s_ana net_name)
  (let ((sig (vtime s_ana net_name)))
    (if (null sig) 0 sig)))

(defun qub::getMosVx (s_ana inst term_name)
  (qub::getNetVoltageSafe s_ana (qub::getInstTermNet inst term_name)))

(defun qub::getMosVxx (s_ana inst term1 term2)
  (difference
    (qub::getMosVx s_ana inst term1)
    (qub::getMosVx s_ana inst term2)))

(defun qub::getMosVds (s_ana inst)
  (qub::getMosVxx s_ana inst "d" "s"))

(defun qub::getMosVsd (s_ana inst)
  (qub::getMosVxx s_ana inst "s" "d"))

(defun qub::getMosVgs (s_ana inst)
  (qub::getMosVxx s_ana inst "g" "s"))

(defun qub::getMosVsg (s_ana inst)
  (qub::getMosVxx s_ana inst "s" "g"))
