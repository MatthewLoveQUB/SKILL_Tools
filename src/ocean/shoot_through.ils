; Calculates the shoot-through current in a CMOS inverter
; May not be totally correct as my method was arrived through intuition
; but it gives me a rough answer that's enough to guage how bad
; the shoot-through current really is.
;
; Args:
;   p: waveform object
;      The waveform of the current flowing through the PMOS(s)
;   n: waveform object
;      The waveform of the current flowing through the NMOS(s)
; Returns:
;  A mutated version of I_N with the shoot-through current
(defun qub::ocnShootThoughCurrent (I_P I_N)
  ; Take the max value after taking the min in the cases where the NMOS current
  ; is negative
  (max 0 (min I_P I_N)))
