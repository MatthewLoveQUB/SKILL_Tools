; Assumes two-port S-parameters
(defun qub::rollett_delta (s11 s12 s21 s22)
  (difference (times s11 s22)
              (times s12 s21)))

(defun qub::mu_stability_factor (s11 s12 s21 s22)
  (let ((D (qub::rollett_delta s11 s12 s21 s22))
        (s11_c (conjugate s11))
        (abs_s12_s21 (abs s12*s21))
        (abs_s11 (abs s11)))
    (quotient (1 - abs_s11**2)
              ((abs s22 - D*s11_c) + abs_s12_s21))))
