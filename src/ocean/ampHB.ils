; For a power amplifier circuit, plot the following:
;     output power
;     gain
;     drain efficiency
;     power added efficiency
;
; Args:
;     out (list net node):
;         The net and node of the output port, represented as strings.
;     in (list net node):
;         The net and node of the input port, represented as strings.
;     supplies (list (list net node) (list net node) ...):
;         The nets and nodes of the power supplies, represented as strings.
;         Unlike out and in, this is a list of lists as you may have
;         multiple inputs.
;     testType (sym): 'hb or 'pss for Harmonic Balance and PSS analyses.
;     pwrInWatts (list of floats or a float): Used for gain and PAE.
(defun qub::ocnAmpHb (@key (out nil)
                           (in nil)
                           (supplies nil)
                           (testType 'hb)
                           (pwrInWatts nil)
                           (sweepMode nil)
                           (nHarmonics 3))
  getPwr = (lambda (x) (pvi testType (car x) 0 (cadr x) 0))

  pwrOutWatts = (getPwr out)
  harmIdxs = (qub::range ?start 1 ?stop nHarmonics+1 ?step 1)
  pwrOutWattsHarms = (qub::lcmp (harmonic pwrOutWatts x) for x in harmIdxs)
  pwrOutWattsF0 = (car pwrOutWattsHarms)
  pwrDc = (qub::sum
            (qub::lcmp (abs (harmonic (getPwr src) 0)) for src in supplies))

  gain = (db10 (pwrOutWattsF0 / pwrInWatts))
  pae = 100.0 * (quotient (pwrOutWattsF0 - pwrInWatts) pwrDc)
  drain_efficiency = 100.0 * (quotient pwrOutWattsF0 pwrDc)

  winId = (newWindow)
  (if (null sweepMode)
      (progn (printf "Pout (f0): %.2f dBm\n" (dBm pwrOutWattsF0))
             (printf "PAE: %.2f%%\n" pae)
             (printf "DE: %.2f%%\n" drain_efficiency)
             (printf "Gain: %.2f dB\n" gain)
             (plot (dbm pwrOutWatts) ?expr (list "Pout")))
      (progn (plot gain drain_efficiency pae
                   ?expr (list "Gain (dB)" "DE (%)" "PAE (%)"))
             (foreach idx (qub::range ?start 0 ?stop nHarmonics ?step 1)
               (plot (dbm (nth idx pwrOutWattsHarms))
                     ?expr (list (sprintf nil "Pout (dBm, %df0)" idx+1)))))))
