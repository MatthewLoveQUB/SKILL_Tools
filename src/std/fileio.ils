(defun qub::listFileRec (rel_path)
  (labels ((helper (pth)
             (if (isFile pth)
                 pth
                 (mapcar (lambda (x) (helper (strcat pth "/" x)))
                         (qub::filterUnwanted (getDirFiles pth))))))
    (qub::flattenList (helper rel_path))))

; Removes . .. and dotted files from list
(defun qub::filterUnwanted (files)
  (setof x files (and (nequal x ".")
                      (nequal x "..")
                      (nequal (getchar x 1) '\.))))

(defun qub::getFileName (path)
  (car (last (parseString path "/"))))

(defun qub::findFilesWithPrefix (files prefix)
  (setof x files (qub::startsWith (qub::getFileName x) prefix)))

(defun qub::findFiles (files name)
  (setof x files (equal name (qub::getFileName x))))
