(addToExportList '(qub:::joinLists
                   qub:::flattenList))

(defun qub::joinLists (lst)
  (qub::foldl append (list) lst))

(defun qub::flattenList (lst)
  (letseq ((outputList (list)))
    (labels  ((helper (a)
              (mapcar (lambda (x)
                        (if (atom x) (pushf x outputList) (helper x)))
                      a)))
      (helper lst)
    (reverse outputList))))
