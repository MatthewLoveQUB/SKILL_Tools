; For mathematics
(defMathConstants 'qub:::m)

; Should be used on floats
(defun qub:::almostEqual (a b @key (rel_tol 1u))
	(when (negativep rel_tol)
		    (error "Can't have negative tolerance"))
	(if (equal a b)
		t
		(let ((diff (abs (difference a b))))
			(cond ((leqp diff rel_tol) t)
					 (t nil)))))

(defun qub:::notAlmostEqual (a b @key (rel_tol 1u))
	(not (qub:::almostEqual a b ?rel_tol rel_tol)))
