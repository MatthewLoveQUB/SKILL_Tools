(addToExportList '(qub:::m
                   qub:::almostEqual
                   qub:::notAlmostEqual))

; For mathematics
(defMathConstants 'qub::m)

; rel_tol 0.1 = 10% difference
; abs_tol is the numerical difference

(defgeneric qub::almostEqual (a b @key (rel_tol 0) (abs_tol 0)))
(defmethod qub::almostEqual ((a number)
                             (b number)
                             @key (rel_tol 0) (abs_tol 0))
  (when (or (negativep rel_tol)
            (negativep abs_tol))
        (error "Can't have negative tolerance"))
  (cond ((equal a b) t)
        ((isInfinity (float a)) nil)
        ((isInfinity (float b)) nil)
        (t (let ((diff (abs (difference a b))))
             (cond ((leqp diff (abs (times rel_tol b))) t)
                   ((leqp diff (abs (times rel_tol a))) t)
                   ((leqp diff abs_tol))
                   (t nil))))))

(defun qub::notAlmostEqual (a b @key (rel_tol 0) (abs_tol 0))
  (not (qub::almostEqual a b ?rel_tol rel_tol ?abs_tol abs_tol)))
