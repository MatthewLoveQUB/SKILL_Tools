; Base class for all Pcells.
; cvId will hold the pcCellView value
(defclass qub::PcellParam ()
  ((cvId @initarg cvId)))

; A simple method to populate the Pcell parameters from the super master to
; a Pcell device's slots
(defmethod qub::setPcellParams ((device qub::PcellParam) cv)
  (when (and cv (dbIsId cv))
    (setSlotValue device 'cvId cv)
    (foreach param cv~>parameters~>value
      (qub::setParamValue device (concat param~>name) param~>value))))

; A function to define a Pcell parameter stored as a Pcell class' slot.
; The optional argument _isParam is set to 't to indicate this parameter is
; a Pcell parameter
(defun qub::defineParam (g_type g_value @optional (_isParam t))
  (list nil 'type g_type 'value g_value 'isParam _isParam))

; A method to get Pcell parameter's type
(defmethod qub::getParamType ((device qub::PcellParam) (propName symbol))
  ((slotValue device propName)->type))

; A method to get Pcell parameter's value
(defmethod qub::getParamValue ((device qub::PcellParam) (propName symbol))
  (slotValue device propName)->value)

; A method to set Pcell parameter's value
(defmethod qub::setParamValue ((device qub::PcellParam) (propName symbol) val)
  ((slotValue device propName)->value = val))

; A method to check is the given name a Pcell parameter or not. This is
; based on the setting of the isParam attribute
(defmethod qub::isParam ((device qub::PcellParam) (propName symbol))
  (slotValue device propName)->isParam)

; A method to get a list of Pcell parameters with their names, types and
; values
(defmethod qub::getPcellParams ((device qub::PcellParam))
  (let ((params nil))
    (setq params (setof p device->? (isParam device p)))
    (setq params (foreach mapcar p params
                   (list p
                         (qub::getParamType device p)
                         (qub::getParamValue device p))))))
