; Base class for all Pcells.
; cvId holds the pcCellView value
(defclass qub::PcellParam ()
  ((cvId @initarg cvId)))

; Populate the Pcell parameters from the super master to a Pcell device's slots
; Args:
;   device: qub::PcellParam
;           The instance that we're mutating
;   cv: cellView instance
(defmethod qub::setPcellParams ((device qub::PcellParam) cv)
  (when (and cv (dbIsId cv))
    (setSlotValue device 'cvId cv)
    (foreach param cv~>parameters~>value
      (qub::setParamValue device (concat param~>name) param~>value))))

; Define a Pcell parameter stored as a Pcell class' slot.
; Args:
;   g_type: string
;           The type of the parameter
;   g_value: The type of g_value should be the same as that stated by g_type
;            e.g. if g_type = "float" then g_value should be a float
;   _isParam: bool
;             Indicates the parameter is an active Pcell parameter
;             Can be used to disable parameters
(defun qub::defineParam (g_type g_value @optional (_isParam t))
  (list nil 'type g_type 'value g_value 'isParam _isParam))

; Get the Pcell parameter's type
(defmethod qub::getParamType ((device qub::PcellParam)
                              (propertyName symbol))
  ((slotValue device propertyName)->type))

; Get the Pcell parameter's value
(defmethod qub::getParamValue ((device qub::PcellParam)
                               (propertyName symbol))
  (slotValue device propertyName)->value)

; Set the Pcell parameter's value
(defmethod qub::setParamValue ((device qub::PcellParam)
                               (propertyName symbol) val)
  ((slotValue device propertyName)->value = val))

; Check is the given name a Pcell parameter or not.
; Based on the setting of the isParam attribute
(defmethod qub::isParam ((device qub::PcellParam)
                         (propertyName symbol))
  (slotValue device propertyName)->isParam)

; Get a list of Pcell parameters with their names, types and values
(defmethod qub::getPcellParams ((device qub::PcellParam))
  (let ((params nil))
    (setq params (setof p device->? (isParam device p)))
    (setq params (foreach mapcar p params
                   (list p
                         (qub::getParamType device p)
                         (qub::getParamValue device p))))))

(defun qub::getPcellBoolParamVal (device param)
  (let ((outStr (qub::getParamValue device param)))
    (cond ((equal outStr "FALSE") nil)
           ((equal outStr "TRUE") t)
           (t (error "drawConnectingBridge is neither 'TRUE' nor 'FALSE'")))))
