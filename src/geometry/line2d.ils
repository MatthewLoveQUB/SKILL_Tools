; Find the intersection point between two lines
; equation taken from here the Line-Line intersection wiki page
(defun qub::findIntersectPoint (a1 a2 b1 b2)
  (let ((x1 (xCoord a1))
        (x2 (xCoord a2))
        (x3 (xCoord b1))
        (x4 (xCoord b2))
        (y1 (yCoord a1))
        (y2 (yCoord a2))
        (y3 (yCoord b1))
        (y4 (yCoord b2)))
    (let ((x1y2 (x1 * y2))
          (y1x2 (y1 * x2))
          (x3y4 (x3 * y4))
          (y3x4 (y3 * x4)))
      (let ((denominator (difference
                           ((x1 - x2) * (y3 - y4))
                           ((y1 - y2) * (x3 - x4)))))
        (let ((px (quotient
                    (difference
                      ((x1y2 - y1x2) * (x3 - x4))
                      ((x1 - x2) * (x3y4 - y3x4)))
                    denominator))
              (py (quotient
                    (difference
                      ((x1y2 - y1x2) * (y3 - y4))
                      ((y1 - y2) * (x3y4 - y3x4)))
                    denominator)))
          px:py)))))
