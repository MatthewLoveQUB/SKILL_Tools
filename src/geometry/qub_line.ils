; Finds the gradient of two lines
(defmethod qub::gradient ((a qub::Point2D) (b qub::Point2D))
  (let ((dx (difference (get_x b) (get_x a)))
        (dy (difference (get_y b) (get_y a))))
    (if (or (zerop dx) (zerop dy))
        0
        (quotient dy dx))))

; Checks if all points are collinear
; i.e. lie on the same straight line
(defmethod qub::collinear? ((points list))
  (let ((ref_point (car points))
        (ref_slope (qub::gradient (car points) (cadr points))))
    (prog ()
      (foreach point (cddr points)
        (when (nequal ref_slope (qub::gradient ref_point point))
              (return)))
      (return t))))

; Using two reference points that are known to be collinear
; and an x or y coordinate, return a coordinate that is
; also on the same line
(defmethod qub::findCollinearPoint ((unknown qub::Point2D)
                                    (ref1 qub::Point2D)
                                    (ref2 qub::Point2D))
  (letseq ((coords (list unknown ref1 ref2))
           (x_values (mapcar get_x coords))
           (y_values (mapcar get_y coords))
           (getn (lambda (lst n) (nth (sub1 n) lst)))
           ; Core is just a variable that needs to be caculated
           ; regardless of whether we're looking for x or y
           (core (difference (times (getn x_values 2) (getn y_values 3))
                             (times (getn x_values 3) (getn y_values 2)))))
     (defun findCollinearHelper (f a b)
       (quotient (f core (times (getn a 1) (difference (getn b 3) (getn b 2))))
                 (difference (getn a 3) (getn a 2))))
     (cond ((null (get_x unknown))
            (qub::makePoint2D (findCollinearHelper plus y_values x_values)
                              (get_y unknown)))
           ((null (get_y unknown))
            (qub::makePoint2D (get_x unknown)
            									; needs sign inverted
            									; i don't know why
            									; probably a bug hiding here somewhere
                              (times -1 (findCollinearHelper difference
                                                   x_values
                                                   y_values))))
           (t (error "Both coordinates shouldn't be known/unknown.")))))
