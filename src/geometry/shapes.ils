; Convert an apothem to a circumradius
; Args:
;   apothem: float
;   num_sides: int or float
(defun qub::apothemToCircumradius (apothem num_sides)
  (quotient apothem (cos (quotient qub::m.PI num_sides))))

; Find the internal angle of a regular polygon
; Args:
;   sides: int or float
(defun qub::internalAngle (sides)
  (quotient 360.0 sides))

; Generate the points of an octagon with a given apothem
; Args:
;   a: float
;      The apothem of the octagon
(defun qub::genOctagon (a)
  (letseq ((angle 45.0)
           (sides 8.0)
           ; circumradius
           (cr (qub::apothemToCircumradius a sides)))
    (qub::lcmp
      ; Want the first point to start at the bottom left
      ; Move by angle/2 clockwise to do this
      ; Polar co-ordinates are used so 90 degrees is north, 0 degrees east etc
      (qub::getPoint (difference 202.5 (times n angle)) cr)
      for n in (qub::range ?start 0 ?stop sides))))

; Generate a list of octagons
; Args:
;   w: float
;      Width of octagon line
;   s: float
;      Spacing between the inner octagon's outer edge and the outer octagon's
;      inner edge
;   a: float
;      Apothem of the innermost octagon
;   n: int or float
;      The number of octagons to be generated
(defun qub::genOctagons (w s a n)
    ; For each octagon, calculate a new apothem and generate the co-ordinates
    (mapcar (lambda (i) (qub::genOctagon (a + w/2.0 + i*(w+s))))
            (qub::range ?start 0 ?stop n)))

; Create a coil from a list of octagons
; Args:
;   shapes: list of octagons which are generated from qub::genOctagons
;   nSegs: int
;          Number of segments of the shape
(defun qub::octagonsToCoil (shapes nSegs)
  (letseq ((inList (qub::joinLists shapes))
           ; Create the output list with the first point added
           (outList (list (nth 0 inList)))
           ; A counter for the required segments
           (segCount 0))
    ; Iterate until we have all of the points
    (while (neq segCount nSegs)
      ; Add the new point to the end of the out list
      (qub::pushEnd (nth (plus 1 segCount) inList) outList)
      ; Increment the counters
      (setq segCount (segCount + 1))
      ; If we've reached the end of a shape
      ; Add the connecting bridge to the next shape
      ; Need to substract the index of the current shape
      ; Due to how we treat segments
      ; Coordinates of the final segment are 7 15 23 etc
      (if (zerop (mod (segCount + 1) 8))
          (letseq ((currentPoint (nth segCount inList))
                   (previousPoint (nth (segCount - 1) inList))
                   (nextPoint (nth (segCount + 1) inList))
                   (lastPointNextShape (nth (segCount + 8) inList))
                   (newPoint (qub::findIntersectPoint previousPoint
                                                      currentPoint
                                                      nextPoint
                                                      lastPointNextShape)))
            ; Find the intersection point between two lines
            ; (1) The last two points of the current shape
            ;     This is a horizontal line.
            ; (2) The first and last points of the next shape
            ;     This is a diagonal line.
            (qub::pushEnd newPoint outList))
          ; Otherwise do nothing
          nil))
    outList))

; Find the co-ordinate for a polygon being generated.
; This is to be used with spiral generation so many of the parameters
; assume you're creating nested shapes that you connect together into a spiral.
; The co-ordinates are for the middle of the line, assuming you're making a 2D
; path where it has width in addition to length.
;
; 0 = half of the internal angle e.g. 45 for a square (??)
; 1 = next point anticlockwise = 135 for a square (??)
;
; Args:
;   polyIdx: integer
;            The index for our current polygon.
;            e.g. polyIdx = 0 means that we're in the centre-most polygon
;            polyIdx=1 would mean that we're in the next shape that encloses it
;   pointIdx: integer
;             The index of the current shape's co-ordinate
;             The upper limit of the index is based on the shape
;             e.g. square shapes would range from 0-3, pentagons 0-4,
;             hexagons 0-5, etc
;   nSides: integer
;           The number of sides of the polygon
;   circumradius: float
;                 Distance from the centre to the middle of a side
;   spacing: float
;            The distance between adjacent paths
;            This is assuming each shape forms a 2D path with width
;   width: float
;          The width of the path formed by the polygon
;   ref: (list float float)
;        Reference co-ordinate for the centre of the shape
;   rotation_anticlockwise: float
;                           The rotation of the shape
(defun qub::getPolyPoint (polyIdx
                          pointIdx
                          nsides
                          circumradius
                          spacing
                          width
                          @key
                          (ref 0.0:0.0)
                          (rotation_anticlockwise 0.0))
  (let ((a2c qub::apothemToCircumradius)
        (fa qub::fixAngle)
        (ia qub::internalAngle)
        (n nsides))
    (let ((d (circumradius + (polyIdx * ((a2c spacing n) + (a2c width n)))))
          (angle (plus
                   (difference 90.0 ((ia nsides) / 2.0))
                   rotation_anticlockwise
                   (pointIdx * (ia nsides)))))
      (qub::getPoint (fa angle) d ?ref ref))))
