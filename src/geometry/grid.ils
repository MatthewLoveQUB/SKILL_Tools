; Rounds values to the nearest 5nm assuming um coords used
; 0.124 will become 0.125, 0.901 to 0.900 etc
(defun qub::roundValue5nm (x)
  (let ((x_round (round (times 1000.0 x)))
        (x_floor (times 10.0 (floor (times 100.0 x)))))
    (cond ((x_round < x_floor + 3) (quotient x_floor 1000.0))
          ((x_round > x_floor + 6) (quotient (plus x_floor 10.0) 1000.0))
          (t (quotient (plus x_floor 5.0) 1000.0)))))

; Apple qub::roundValue5nm to a two-element list
(defun qub::roundCoord5nm (x)
  (list (qub::roundValue5nm (car x)) (qub::roundValue5nm (cadr x))))
