;;;; All coordinates assume polar plot
;;;; e.g. 0 degrees is east, 90 degrees is north etc

; Restrict a number between 0 and 360
; Args:
;   angle: float or int
(defgeneric qub::fixAngle (angle))

(defmethod qub::fixAngle ((angle fixnum))
  (modulo angle 360))

(defmethod qub::fixAngle ((angle flonum))
  (if (negativep angle)
      (plus 360.0 (modf angle 360.0))
  (modf angle 360.0)))

; Convert angle in degrees to radians
; Args:
;   angle: float
(defun qub::degToRad (angle)
  (times
    qub::m.PI
    (quotient
      angle
      180.0)))

; Convert an angle from radians to degrees
; Args:
;   angle: float
(defun qub::radToDeg (angle)
  (times 180.0 (quotient angle qub::m.PI)))
