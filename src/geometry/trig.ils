;;;; file for generating spiral inductors
;;;; only use floats for coordinates
;;;; 0 degrees is east. 90 degrees is north

(defgeneric qub::fixAngle (angle))

(defmethod qub::fixAngle ((angle fixnum))
  (modulo angle 360))

(defmethod qub::fixAngle ((angle flonum))
  (if (negativep angle)
      (plus 360.0 (modf angle 360.0))
  (modf angle 360.0)))

; Degrees to radians
(defun qub::degToRad (value)
  (times
    qub::m.PI
    (quotient
      value
      180.0)))

(defun qub::radToDeg (value)
  (times 180.0 (quotient value qub::m.PI)))
