(defun qub::adeDirectPlot ()
  (sevDirectPlot (sevSession (getCurrentWindow)) 'asiDirectPlotResultsMenuCB))
