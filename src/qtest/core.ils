(defclass qtest:::Result ()
	; Result can be 'Pass or 'Fail
	((result @initarg result
					 @reader get_result
					 @writer set_result)
	 (msg	@initarg msg
	 			@reader get_msg
	 			@writer set_msg)
	 (inputs @initarg inputs
	 				 @reader get_inputs
	 				 @writer set_inputs)))

(defmethod printself ((obj qtest:::Result))
	(sprintf nil
				"Test Result\nResult: %s\nMessage: %s\nInputs (%n):%A"
				(get_result obj)
				(get_msg obj)
				(length (get_inputs obj))
				(get_inputs obj)))

(defun qtest:::makeResult (result msg inputs)
	(makeInstance 'qtest:::Result
								?result result
								?msg msg
								?inputs inputs))

; Create function and return a list of its name and
; the function object. To be used inside qtest:::TestRunner
(defmacro qtest:::TestCase (fn_name @rest body)
`(let ((f (lambda () ,@body)))
		(list ',fn_name f)))

; Test runner. Automatically called by the test suite
(defun qtest:::runTests (tests)
	(letseq ((results (mapcar (lambda (x) (list (car x) (funcall (cadr x)))) tests))
					 (fails (setof r results (eq 'Fail (get_result (cadr r)))))
					 (formatted_results (mapcar (lambda (x) (sprintf nil
					 																								 "Test failure: %s\nMsg: %s\nInputs:%A"
					 																								 (car x)
					 																								 (get_msg (cadr x))
					 																								 (get_inputs (cadr x))))
					 														fails)))
		formatted_results))

; Runs each of the tests defined in the body
(defmacro qtest:::TestSuite (let_lst @rest tests)
	`(let ,let_lst
		(list ,@tests)))

(defun qtest:::runSuites (@rest suites)
	(letseq ((tests (qub:::join_lists suites))
					 (ntests (length tests))
				   (failures (qtest:::runTests tests))
				   (nfailures (length failures)))
		(printf "%n of %n tests passed (%n failures).\n"
						(difference ntests nfailures)
						ntests
						nfailures)
		(mapc (lambda (x) (printf "%s\n" x)) failures)))
