(defclass qtest:::Result ()
	; Result can be 'Pass or 'Fail
	((result @initarg result
					 @reader get_result
					 @writer set_result)
	 (msg	@initarg msg
	 			@reader get_msg
	 			@writer set_msg)))

(defun qtest:::makeResult (result msg)
	(makeInstance 'qtest:::Result
								?result result
								?msg msg))

; Create function and return a list of its name and
; the function object. To be used inside qtest:::TestRunner
(defmacro qtest:::TestCase (fn_name @rest body)
`(let ((f (lambda () ,@body)))
		(list ',fn_name f)))

; Test runner. Automatically called by the test suite
(defun qtest:::runTests (tests)
	(letseq ((results (mapcar (lambda (x) (list (car x) (funcall (cadr x)))) tests))
					 (fails (setof x results (eq 'Fail (get_result (cadr x)))))
					 (formatted_results (mapcar (lambda (x) (sprintf nil
					 																								 "%s failed: %s"
					 																								 (car x)
					 																								 (get_msg (cadr x))))
					 														fails)))
		formatted_results))

; Runs each of the tests defined in the body
(defun qtest:::TestSuite (@rest tests)
	tests)

(defun qtest:::runSuites (@rest suites)
	(letseq ((tests (append suites))
					 (ntests (length tests))
				   (failures (qtest:::runTests tests))
				   (nfailures (length failures)))
		(printf "%n of %n tests failed.\n" nfailures ntests)
		(mapc (lambda (x) (printf "%s\n" x)) failures)))
