(defclass qtest:::Result ()
  ; Result can be 'Pass or 'Fail
  ((result @initarg result
           @reader get_result
           @writer set_result)
   (msg @initarg msg
        @reader get_msg
        @writer set_msg)
   (inputs @initarg inputs
           @reader get_inputs
           @writer set_inputs)
   (evaluated_inputs @initarg evaluated_inputs
                     @reader get_evaluated_inputs
                     @writer set_evaluated_inputs)))

(defmethod printself ((obj qtest:::Result))
  (sprintf nil
"Result: %s\n
Message: %s\n
Inputs: %A\n
Evaluated Inputs: %A\n"
        (get_result obj)
        (get_msg obj)
        (get_inputs obj)
        (get_evaluated_inputs obj)))

(defun qtest:::makeResult (result msg inputs evaluated_inputs)
  (makeInstance 'qtest:::Result
                ?result result
                ?msg msg
                ?inputs inputs
                ?evaluated_inputs evaluated_inputs))

; Create function and return a list of its name and
; the function object. To be used inside qtest:::TestRunner
(defmacro qtest:::TestCase (fn_name @key (skip nil) @rest body)
  (if skip
    `(list ',fn_name
           (lambda ()
             (qtest:::makeResult 'Skip
                                 "Test was skipped"
                                 ()
                                 ())))
    `(let ((f (lambda () ,@body)))
        (list ',fn_name f))))

; Test runner. Automatically called by the test suite
; Returns a list containing (fn name (symbol), qub::Result)
(defun qtest:::runTests (tests)
  (mapcar (lambda (x) (list (car x) (funcall (cadr x)))) tests))

; Runs each of the tests defined in the body
(defmacro qtest:::TestSuite (let_lst @rest tests)
  `(let ,let_lst
    (list ,@tests)))

(defun qtest:::runSuites (@rest suites)
  (letseq ((tests (qub:::join_lists suites))
           (results (qtest:::runTests tests))
           (ntests (length tests))
           (fails (setof x results (eq 'Fail (get_result (cadr x)))))
           (nfails (length fails))
           (skipped (setof x results (eq 'Skip (get_result (cadr x)))))
           (nskipped (length skipped))
           (npassed (difference ntests nfails nskipped)))
    (printf "%n of %n tests passed (%n failures) (%n skipped).\n"
            npassed
            ntests
            nfails
            nskipped)
    (mapc (lambda (x) (printf "%s\n" x)) fails)
    (printf "\n")))

(defun qtest:::runAllTests (rel_path)
  (letseq ((files_in_dir (qub:::listFileRec rel_path))
           (get_file_name (lambda (x) (car (last (parseString x "/")))))
           (test_files (setof x
                              files_in_dir
                              (qub:::starts_with (get_file_name x) "test_"))))
    (mapc (lambda (x)
            (printf "Running: %s\n" x)
            (load x))
          test_files)))

(addToExportList '(qtest:::TestCase
                   qtest:::runTests
                   qtest:::TestSuite
                   qtest:::runSuites
                   qtest:::runAllTests))
