(defun qtest:::assert (test
                       quoted_inputs
                       evaluated_inputs
                       @key (msg "No msg."))
  (if test
      (qtest:::makeResult 'Pass msg quoted_inputs evaluated_inputs)
      (qtest:::makeResult 'Fail msg quoted_inputs evaluated_inputs)))

(defmacro qtest:::assertEqual (a b @key (msg "No msg."))
  `(letseq ((x (gensym))
            (y (gensym)))
    (setq x ,a)
    (setq y ,b)
    (qtest:::assert (qub:::equal x y)
                    (list ',a ',b)
                    (list x y)
                    ?msg ,msg)))

(defmacro qtest:::assertNotEqual (a b @key (msg "No msg."))
  `(letseq ((x (gensym))
            (y (gensym)))
    (setq x ,a)
    (setq y ,b)
    (qtest:::assert (qub:::nequal ,a ,b)
                    (list ',a ',b)
                    (list ,a ,b)
                    ?msg ,msg)))

(defmacro qtest:::assertTrue (x @key (msg "No msg."))
  `(letseq ((a (gensym)))
    (setq a ,x)
    (qtest:::assert (not (null a))
                    (list ',x)
                    (list a)
                    ?msg ,msg)))

(defmacro qtest:::assertNil (x @key (msg "No msg."))
  `(letseq ((a (gensym)))
    (setq a ,x)
    (qtest:::assert (null a)
                    (list ',x)
                    (list a)
                    ?msg ,msg)))

(defmacro qtest:::assertEq (a b @key (msg "No msg."))
  `(letseq ((x (gensym))
            (y (gensym)))
    (setq x ,a)
    (setq y ,b)
    (qtest:::assert (eq x y)
                    (list ',a ',b)
                    (list x y)
                    ?msg ,msg)))

(defmacro qtest:::assertNotEq (a b @key (msg "No msg."))
  `(letseq ((x (gensym))
            (y (gensym)))
    (setq x ,a)
    (setq y ,b)
    (qtest:::assert (neq x y)
                    (list ',a ',b)
                    (list x y)
                    ?msg ,msg)))

(defmacro qtest:::assertMember (value lst @key (msg "No msg."))
  `(letseq ((x (gensym))
            (y (gensym)))
    (setq x ,value)
    (setq y ,lst)
    (qtest:::assert (member x y)
                    (list ',value ',lst)
                    (list x y)
                    ?msg ,msg)))

(defmacro qtest:::assertNotMember (value lst @key (msg "No msg."))
  `(letseq ((x (gensym))
            (y (gensym)))
    (setq x ,value)
    (setq y ,lst)
    (qtest:::assert (not (member x y))
                    (list ',value ',lst)
                    (list x y)
                    ?msg ,msg)))

(defmacro qtest:::assertIsInstance (obj cls @key (msg "No msg."))
  `(letseq ((x (gensym))
            (y (gensym)))
    (setq x ,obj)
    (setq y ,cls)
    (qtest:::assert (classp x (findClass y))
                    (list ',obj ',cls)
                    (list x y)
                    ?msg ,msg)))

(defmacro qtest:::assertNotIsInstance (obj cls @key (msg "No msg."))
  `(letseq ((x (gensym))
            (y (gensym)))
    (setq x ,obj)
    (setq y ,cls)
    (qtest:::assert (not (classp x (findClass y)))
                    (list ',obj ',cls)
                    (list x y)
                    ?msg ,msg)))

(defmacro qtest:::raised (fn)
  `(let ((exception_occured (gensym)))
    (setq exception_occured t)
    (catch t
      ,fn
      (setq exception_occured nil))
    exception_occured))

(defmacro qtest:::assertRaises (fn @key (msg "No msg."))
  `(qtest:::assert (qtest:::raised ,fn)
                   (list ',fn)
                   (list "Can't include it as it's meant to fail")
                   ?msg ,msg))

(defmacro qtest:::assertAlmostEqual (a b @key (rel_tol 0) (abs_tol 0) (msg "No msg"))
  `(letseq ((x (gensym))
            (y (gensym)))
    (setq x ,a)
    (setq y ,b)
    (qtest:::assert (qub:::almostEqual x y ?rel_tol ,rel_tol ?abs_tol ,abs_tol)
                    (list ',a ',b ',rel_tol ',abs_tol)
                    (list x y ,rel_tol ,abs_tol)
                    ?msg ,msg)))

(defmacro qtest:::assertNotAlmostEqual (a b @key (rel_tol 0) (abs_tol 0) (msg "No msg"))
  `(letseq ((x (gensym))
            (y (gensym)))
    (setq x ,a)
    (setq y ,b)
    (qtest:::assert (qub:::notAlmostEqual x y ?rel_tol ,rel_tol ?abs_tol ,abs_tol)
                    (list ',a ',b ',rel_tol ',abs_tol)
                    (list x y ,rel_tol ,abs_tol)
                    ?msg ,msg)))

(addToExportList '(qtest:::assertEqual
                   qtest:::assertNotEqual
                   qtest:::assertTrue
                   qtest:::assertNil
                   qtest:::assertEq
                   qtest:::assertNotEq
                   qtest:::assertMember
                   qtest:::assertNotMember
                   qtest:::assertIsInstance
                   qtest:::assertNotIsInstance
                   qtest:::assertRaises
                   qtest:::assertAlmostEqual
                   qtest:::assertNotAlmostEqual))
