(defun qtest:::assert (test test_inputs @optional (msg "No msg."))
	(if test
			(qtest:::makeResult 'Pass msg test_inputs)
			(qtest:::makeResult 'Fail msg test_inputs)))

(defmacro qtest:::assertEqual (a b @optional (msg "No msg."))
	`(qtest:::assert (qub:::equal ,a ,b) (list ',a ',b) ,msg))

(defmacro qtest:::assertNotEqual (a b @optional (msg "No msg."))
	`(qtest:::assert (qub:::nequal ,a ,b) (list ',a ',b) ,msg))

(defmacro qtest:::assertTrue (x @optional (msg "No msg."))
	`(qtest:::assert (not (null ,x)) (list ',x) ,msg))

(defmacro qtest:::assertNil (x @optional (msg "No msg."))
	`(qtest:::assert (null ,x) (list ',x) ,msg))

(defmacro qtest:::assertEq (a b @optional (msg "No msg."))
	`(qtest:::assert (eq ,a ,b) (list ',a ',b) ,msg))

(defmacro qtest:::assertNotEq (a b @optional (msg "No msg."))
	`(qtest:::assert (neq ,a ,b) (list ',a ',b) ,msg))

(defmacro qtest:::assertMember (value lst @optional (msg "No msg."))
	`(qtest:::assert (member ,value ,lst) (list ',value ',lst) ,msg))

(defmacro qtest:::assertNotMember (value lst @optional (msg "No msg."))
	`(qtest:::assert (not (member ,value ,lst)) (list ',value ',lst) ,msg))

(defmacro qtest:::assertIsInstance (obj cls @optional (msg "No msg."))
	`(qtest:::assert (classp ,obj (findClass ,cls)) (list ',obj ',cls) ,msg))

(defmacro qtest:::assertNotIsInstance (obj cls @optional (msg "No msg."))
	`(qtest:::assert (not (classp ,obj (findClass ,cls))) (list ',obj ',cls) ,msg))

(defmacro qtest:::assertRaises (fn @optional (msg "No msg."))
	`(qtest:::assert (null (errset (,fn))) (list ',fn) ,msg)))

(defmacro qtest:::assertAlmostEqual (a b @optional (msg "No msg"))
	`(qtest:::assert (qub:::almostEqual ,a ,b) (list ',a ',b) ,msg))

(defmacro qtest:::assertNotAlmostEqual (a b @optional (msg "No msg"))
	`(qtest:::assert (qub:::notAlmostEqual ,a ,b) (list ',a ',b) ,msg))
