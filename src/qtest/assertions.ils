(defun qtest:::assert (test quoted_inputs evaluated_inputs  @key (msg "No msg."))
	(if test
			(qtest:::makeResult 'Pass msg quoted_inputs evaluated_inputs)
			(qtest:::makeResult 'Fail msg quoted_inputs evaluated_inputs)))

; These evaluate the inputs multiple times
; May be  a source of bugs
; Maybe wrap the inputs in a let and use apply which will return the assert result
(defmacro qtest:::assertEqual (a b @key (msg "No msg."))
	`(qtest:::assert (qub:::equal ,a ,b)
									 (list ',a ',b)
									 (list ,a ,b)
									 ?msg ,msg))

(defmacro qtest:::assertNotEqual (a b @key (msg "No msg."))
	`(qtest:::assert (qub:::nequal ,a ,b)
									 (list ',a ',b)
									 (list ,a ,b)
									 ?msg ,msg))

(defmacro qtest:::assertTrue (x @key (msg "No msg."))
	`(qtest:::assert (not (null ,x))
									 (list ',x)
									 (list ,x)
									 ?msg ,msg))

(defmacro qtest:::assertNil (x @key (msg "No msg."))
	`(qtest:::assert (null ,x)
									 (list ',x)
									 (list ,x)
									 ?msg ,msg))

(defmacro qtest:::assertEq (a b @key (msg "No msg."))
	`(qtest:::assert (eq ,a ,b)
									 (list ',a ',b)
									 (list ,a ,b)
									 ?msg ,msg))

(defmacro qtest:::assertNotEq (a b @key (msg "No msg."))
	`(qtest:::assert (neq ,a ,b)
									 (list ',a ',b)
									 (list ,a ,b)
									 ?msg ,msg))

(defmacro qtest:::assertMember (value lst @key (msg "No msg."))
	`(qtest:::assert (member ,value ,lst)
									 (list ',value ',lst)
									 (list ,value ,lst)
									 ?msg ,msg))

(defmacro qtest:::assertNotMember (value lst @key (msg "No msg."))
	`(qtest:::assert (not (member ,value ,lst))
									 (list ',value ',lst)
									 (list ,value ,lst)
									 ?msg ,msg))

(defmacro qtest:::assertIsInstance (obj cls @key (msg "No msg."))
	`(qtest:::assert (classp ,obj (findClass ,cls))
									 (list ',obj ',cls)
									 (list ,obj ,cls)
									 ?msg ,msg))

(defmacro qtest:::assertNotIsInstance (obj cls @key (msg "No msg."))
	`(qtest:::assert (not (classp ,obj (findClass ,cls)))
									 (list ',obj ',cls)
									 (list ,obj ,cls)
									 ?msg ,msg))

(defmacro qtest:::assertRaises (fn @key (msg "No msg."))
	`(qtest:::assert (null (errset (,fn)))
									 (list ',fn)
									 (list "Can't include it as it's meant to fail")
									 ?msg ,msg)))

(defmacro qtest:::assertAlmostEqual (a b @key (rel_tol 1u) (msg "No msg"))
	`(qtest:::assert (qub:::almostEqual ,a ,b ?rel_tol ,rel_tol)
									 (list ',a ',b ',rel_tol)
									 (list ,a ,b ,rel_tol)
									 ?msg ,msg))

(defmacro qtest:::assertNotAlmostEqual (a b @key (rel_tol 1u) (msg "No msg"))
	`(qtest:::assert (qub:::notAlmostEqual ,a ,b ?rel_tol ,rel_tol)
									 (list ',a ',b ',rel_tol)
									 (list ,a ,b ,rel_tol)
									 ?msg ,msg))
