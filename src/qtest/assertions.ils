(defun qtest:::assert (test test_inputs @optional (msg "No msg."))
	(if test
			(qtest:::makeResult 'Pass msg test_inputs)
			(qtest:::makeResult 'Fail msg test_inputs)))

(defun qtest:::assertEqual (a b @optional (msg "No msg."))
	(qtest:::assert (qub:::equal a b) (list a b) msg))

(defun qtest:::assertNotEqual (a b @optional (msg "No msg."))
	(qtest:::assert (qub:::nequal a b) (list a b)))

(defun qtest:::assertTrue (x @optional (msg "No msg."))
	(qtest:::assert (not (null x)) x))

(defun qtest:::assertNil (x @optional (msg "No msg."))
	(qtest:::assert (null x) x))

(defun qtest:::assertEq (a b @optional (msg "No msg."))
	(qtest:::assert (eq a b) (list a b) msg))

(defun qtest:::assertNotEq (a b @optional (msg "No msg."))
	(qtest:::assert (neq a b) (list a b) msg))

(defun qtest:::assertMember (value lst @optional (msg "No msg."))
	(qtest:::assert (member value lst) (list value lst) msg))

(defun qtest:::assertNotMember (value lst @optional (msg "No msg."))
	(qtest:::assert (not (member value lst)) (list value lst) msg))

(defun qtest:::assertIsInstance (obj cls @optional (msg "No msg."))
	(qtest:::assert (classp obj (findClass cls)) (list obj cls) msg))

(defun qtest:::assertNotIsInstance (obj cls @optional (msg "No msg."))
	(qtest:::assert (not (classp obj (findClass cls))) (list obj cls) msg))

(defun qtest:::assertRaises (fn args @optional (msg "No msg."))
	(qtest:::assert (null (errset (apply fn args))) (list fn args) msg))
