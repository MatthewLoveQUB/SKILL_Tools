(unless (findNamespace "qtest")
				(makeNamespace "qtest"))

(defclass qtest:::Result ()
	; Result can be 'Pass or 'Fail
	((result @initarg result
					 @reader get_result
					 @writer set_result)
	 (msg	@initarg msg
	 			@reader get_msg
	 			@writer set_msg)))

(defun qtest:::makeResult (result msg)
	(makeInstance 'qtest:::Result
								?result result
								?msg msg))

; Create function and return a list of its name and
; the function object. To be used inside qtest:::TestRunner
(defmacro qtest:::TestCase (fn_name @rest body)
`(let ((f (lambda () ,@body)))
		(list ',fn_name f)))

; Assertion Functions
(defun qtest:::assert (test @optional (msg "No msg."))
	(if test
			(qtest:::makeResult 'Pass msg)
			(qtest:::makeResult 'Fail msg)))

(defun qtest:::assertEqual (a b @optional (msg "No msg."))
	(qtest:::assert (equal a b) msg))

(defun qtest:::assertNotEqual (a b @optional (msg "No msg."))
	(assert (nequal a b) msg))

(defun qtest:::runTest (test result_list)
	(let ((test_result (funcall (cadr test))))
		(when (eq 'Fail (get_result test_result))
					(sprintf nil
									 "%s failed: %s"
									 (car test)
									 (get_msg test_result)))))

(defun qtest:::TestSuite (@rest tests)
	(let ((ntests (length tests))
				(failures (list)))
		(foreach test tests
			(pushf (qtest:::runTest test failures) failures))
		(printf "%n of %n tests failed.\n"
						(sub1 (length failures))
						ntests)))

(qtest:::TestSuite
	(qtest:::TestCase t1 ()
		(qtest:::assertEqual 2 2 "Checking equality"))
	(qtest:::TestCase t2 ()
		(qtest:::assertEqual 1 2 "Should fail.")))
