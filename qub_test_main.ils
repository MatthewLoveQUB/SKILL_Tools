(unless (findNamespace "qtest")
				(makeNamespace "qtest"))

(defclass qtest:::Result ()
	; Result can be 'Pass or 'Fail
	((result @initarg result
					 @reader get_result
					 @writer set_result)
	 (msg	@initarg msg
	 			@reader get_msg
	 			@writer set_msg)))

(defun qtest:::makeResult (result msg)
	(makeInstance 'qtest:::Result
								?result result
								?msg msg))

; Create function and return a list of its name and
; the function object. To be used inside qtest:::TestRunner
(defmacro qtest:::TestCase (fn_name @rest body)
`(let ((f (lambda () ,@body)))
		(list ',fn_name f)))

; Assertion Functions
(defun qtest:::assert (test @optional (msg "No msg."))
	(if test
			(qtest:::makeResult 'Pass msg)
			(qtest:::makeResult 'Fail msg)))

(defun qtest:::assertEqual (a b @optional (msg "No msg."))
	(qtest:::assert (equal a b) msg))

(defun qtest:::assertNotEqual (a b @optional (msg "No msg."))
	(assert (nequal a b) msg))

; Test runner. Automatically called by the test suite
(defun qtest:::runTests (tests)
	(letseq ((results (mapcar (lambda (x) (list (car x) (funcall (cadr x)))) tests))
					 (fails (setof x results (eq 'Fail (get_result (cadr x)))))
					 (formatted_results (mapcar (lambda (x) (sprintf nil
					 																								 "%s failed: %s"
					 																								 (car x)
					 																								 (get_msg (cadr x))))
					 														fails)))
		formatted_results))

; Runs each of the tests defined in the body
(defun qtest:::TestSuite (@rest tests)
	(letseq ((ntests (length tests))
				   (failures (qtest:::runTests tests))
				   (nfailures (length failures)))
		(printf "%n of %n tests failed.\n" nfailures ntests)
		(mapc (lambda (x) (printf "%s\n" x)) failures)))

(qtest:::TestSuite
	(qtest:::TestCase t1 ()
		(qtest:::assertEqual 2 2 "Checking equality"))
	(qtest:::TestCase t2 ()
		(qtest:::assertEqual 1 2 "Should fail.")))
