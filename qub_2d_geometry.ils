; Using polar coordinates so east is 0 degrees, north 90 etc

; Ensures an angle can't go beyond 360 degrees
(defun qub:::fix_angle (angle "n")
  (mod angle 360))

; Represents a point in 2D space
(defclass qub:::Point2D ()
  ((x @initarg x
      @writer set_x
      @reader get_x)
   (y @initarg y
      @writer set_y
      @reader get_y)))

; Helper function
(defun qub:::makePoint2D (x y)
	(makeInstance 'Point2D ?x x ?y y))

; Represents a rotation action
(defclass qub:::Rotation ()
  ((angle @initarg angle
          @writer set_angle
          @reader get_angle)
   (direction @initarg direction
              @writer set_direction
              @reader get_direction)))

; Applies a rotation to a state
(defgeneric qub:::rotate (target rotation))
(defmethod rotate ((target State2D) (rotation Rotation))
  (letseq ((f (caseq (get_direction rotation)
                (clockwise difference)
                (anticlockwise plus)))
           (new_angle (f (get_angle target)
                         (get_angle rotation))))
    (makeState2D new_angle (get_pos target))))
